* NGSPICE file created from gf180mcu_as_sc_mcu7t3v3__and2_2.ext - technology: gf180mcuD

.subckt gf180mcu_as_sc_mcu7t3v3__and2_2 VDD VNW VPW VSS B A Y
X0 VDD.t0 B.t1 a_28_68# VNW.t2 pfet_03v3 ad=0.3588p pd=1.9u as=0.3588p ps=1.9u w=1.38u l=0.28u
X1 a_172_68# A.t0 a_28_68# VPW.t3 nfet_03v3 ad=0.26p pd=1.52u as=0.44p ps=2.88u w=1u l=0.28u
X2 Y.t0 a_28_68# VDD.t1 VNW.t0 pfet_03v3 ad=0.3588p pd=1.9u as=0.3588p ps=1.9u w=1.38u l=0.28u
X3 VSS.t2 a_28_68# Y.t3 VPW.t1 nfet_03v3 ad=0.52p pd=3.04u as=0.26p ps=1.52u w=1u l=0.28u
X4 VDD.t2 a_28_68# Y.t1 VNW.t1 pfet_03v3 ad=0.7176p pd=3.8u as=0.3588p ps=1.9u w=1.38u l=0.28u
X5 Y.t2 a_28_68# VSS.t1 VPW.t0 nfet_03v3 ad=0.26p pd=1.52u as=0.26p ps=1.52u w=1u l=0.28u
X6 a_28_68# A.t1 VDD.t3 VNW.t3 pfet_03v3 ad=0.3588p pd=1.9u as=0.6072p ps=3.64u w=1.38u l=0.28u
X7 VSS.t0 B.t0 a_172_68# VPW.t2 nfet_03v3 ad=0.26p pd=1.52u as=0.26p ps=1.52u w=1u l=0.28u
R0 VSS.n1 VSS.n0 6.38659
R1 VSS.n1 VSS.t2 5.2398
R2 VSS.n0 VSS.t1 1.6385
R3 VSS.n0 VSS.t0 1.6385
R4 VSS VSS.n1 0.2885
R5 Y.n2 Y.n1 6.3005
R6 Y.n2 Y.n0 2.94794
R7 Y.n1 Y.t3 1.6385
R8 Y.n1 Y.t2 1.6385
R9 Y.n0 Y.t1 1.31934
R10 Y.n0 Y.t0 1.31934
R11 Y Y.n2 0.0465465
R12 VDD.n2 VDD.t3 13.4002
R13 VDD.n1 VDD.n0 5.28659
R14 VDD.n1 VDD.t2 3.57833
R15 VDD.n0 VDD.t1 1.31934
R16 VDD.n0 VDD.t0 1.31934
R17 VDD.n2 VDD.n1 0.2405
R18 VDD VDD.n2 0.0485
R19 B.n0 B.t1 27.5107
R20 B.n0 B.t0 22.5169
R21 B B.n0 8.02014
R22 A.n0 A.t1 27.2902
R23 A.n0 A.t0 22.7374
R24 A A.n0 8.09156
R25 VNW.t0 VNW.t1 310.079
R26 VNW.t2 VNW.t0 310.079
R27 VNW.t3 VNW.t2 310.079
R28 VNW VNW.t3 259.69
R29 VPW.t0 VPW.t1 1181.82
R30 VPW.t2 VPW.t0 1181.82
R31 VPW.t3 VPW.t2 1181.82
R32 VPW VPW.t3 989.774
C0 VSS VNW 0.00544f
C1 A VSS 0.01271f
C2 a_172_68# VSS 0.00814f
C3 VSS VDD 0.03379f
C4 VSS Y 0.11262f
C5 VSS a_28_68# 0.244f
C6 VNW B 0.07769f
C7 A B 0.08818f
C8 a_172_68# B 0
C9 B VDD 0.01873f
C10 B Y 0
C11 B a_28_68# 0.43668f
C12 A VNW 0.08344f
C13 VNW VDD 0.12834f
C14 VNW Y 0.02198f
C15 VNW a_28_68# 0.1919f
C16 A VDD 0.04399f
C17 a_172_68# VDD 0
C18 A Y 0
C19 VDD Y 0.28024f
C20 A a_28_68# 0.10005f
C21 a_172_68# a_28_68# 0.01319f
C22 VDD a_28_68# 0.20144f
C23 VSS B 0.01447f
C24 Y a_28_68# 0.26767f
C25 VSS VPW 0.39641f
C26 Y VPW 0.04197f
C27 VDD VPW 0.26034f
C28 B VPW 0.30179f
C29 A VPW 0.20993f
C30 VNW VPW 1.56664f
C31 a_28_68# VPW 0.26969f
C32 VNW.t1 VPW 0.1735f
C33 VNW.t0 VPW 0.08515f
C34 VNW.t2 VPW 0.08515f
C35 VNW.t3 VPW 0.07823f
C36 A.t1 VPW 0.08284f
C37 A.t0 VPW 0.06029f
C38 A.n0 VPW 0.10421f
C39 B.t1 VPW 0.14554f
C40 B.t0 VPW 0.10474f
C41 B.n0 VPW 0.18153f
C42 VDD.t3 VPW 0.07074f
C43 VDD.t1 VPW 0.02581f
C44 VDD.t0 VPW 0.02581f
C45 VDD.n0 VPW 0.05177f
C46 VDD.t2 VPW 0.08782f
C47 VDD.n1 VPW 0.31848f
C48 VDD.n2 VPW 0.11238f
C49 Y.t1 VPW 0.05334f
C50 Y.t0 VPW 0.05334f
C51 Y.n0 VPW 0.12809f
C52 Y.t3 VPW 0.03866f
C53 Y.t2 VPW 0.03866f
C54 Y.n1 VPW 0.07731f
C55 Y.n2 VPW 0.28035f
C56 VSS.t1 VPW 0.01496f
C57 VSS.t0 VPW 0.01496f
C58 VSS.n0 VPW 0.03002f
C59 VSS.t2 VPW 0.05195f
C60 VSS.n1 VPW 0.25298f
.ends

* NGSPICE file created from gf180mcu_as_sc_mcu7t3v3__and2_4.ext - technology: gf180mcuD

.subckt gf180mcu_as_sc_mcu7t3v3__and2_4 VDD VNW VPW VSS B A Y
X0 VSS.t0 a_28_68# Y.t6 VPW.t3 nfet_03v3 ad=0.6p pd=3.2u as=0.26p ps=1.52u w=1u l=0.28u
X1 VDD.t5 B.t1 a_28_68# VNW.t4 pfet_03v3 ad=0.3588p pd=1.9u as=0.3588p ps=1.9u w=1.38u l=0.28u
X2 Y.t2 a_28_68# VDD.t2 VNW.t2 pfet_03v3 ad=0.3588p pd=1.9u as=0.3588p ps=1.9u w=1.38u l=0.28u
X3 a_172_68# A.t0 a_28_68# VPW.t5 nfet_03v3 ad=0.26p pd=1.52u as=0.44p ps=2.88u w=1u l=0.28u
X4 Y.t5 a_28_68# VSS.t2 VPW.t2 nfet_03v3 ad=0.26p pd=1.52u as=0.26p ps=1.52u w=1u l=0.28u
X5 Y.t0 a_28_68# VDD.t0 VNW.t0 pfet_03v3 ad=0.3588p pd=1.9u as=0.3588p ps=1.9u w=1.38u l=0.28u
X6 VDD.t3 a_28_68# Y.t7 VNW.t3 pfet_03v3 ad=0.828p pd=3.96u as=0.3588p ps=1.9u w=1.38u l=0.28u
X7 VSS.t3 a_28_68# Y.t4 VPW.t1 nfet_03v3 ad=0.26p pd=1.52u as=0.26p ps=1.52u w=1u l=0.28u
X8 VDD.t1 a_28_68# Y.t1 VNW.t1 pfet_03v3 ad=0.3588p pd=1.9u as=0.3588p ps=1.9u w=1.38u l=0.28u
X9 Y.t3 a_28_68# VSS.t1 VPW.t0 nfet_03v3 ad=0.26p pd=1.52u as=0.26p ps=1.52u w=1u l=0.28u
X10 a_28_68# A.t1 VDD.t4 VNW.t5 pfet_03v3 ad=0.3588p pd=1.9u as=0.6072p ps=3.64u w=1.38u l=0.28u
X11 VSS.t4 B.t0 a_172_68# VPW.t4 nfet_03v3 ad=0.26p pd=1.52u as=0.26p ps=1.52u w=1u l=0.28u
R0 VSS.n3 VSS.n0 6.38659
R1 VSS.n2 VSS.t0 5.2398
R2 VSS.n2 VSS.n1 3.3618
R3 VSS.n1 VSS.t2 1.6385
R4 VSS.n1 VSS.t3 1.6385
R5 VSS.n0 VSS.t1 1.6385
R6 VSS.n0 VSS.t4 1.6385
R7 VSS VSS.n3 0.2885
R8 VSS.n3 VSS.n2 0.2405
R9 Y.n2 Y.n1 6.51572
R10 Y.n6 Y.n5 6.3005
R11 Y.n2 Y.n0 2.94485
R12 Y.n4 Y.n3 2.82721
R13 Y.n5 Y.t6 1.6385
R14 Y.n5 Y.t5 1.6385
R15 Y.n1 Y.t4 1.6385
R16 Y.n1 Y.t3 1.6385
R17 Y.n3 Y.t7 1.31934
R18 Y.n3 Y.t2 1.31934
R19 Y.n0 Y.t1 1.31934
R20 Y.n0 Y.t0 1.31934
R21 Y.n4 Y.n2 0.581587
R22 Y.n6 Y.n4 0.157715
R23 Y Y.n6 0.0449304
R24 VDD.n4 VDD.t4 13.4002
R25 VDD.n3 VDD.n0 5.28659
R26 VDD.n2 VDD.t3 3.57833
R27 VDD.n2 VDD.n1 2.01949
R28 VDD.n0 VDD.t0 1.31934
R29 VDD.n0 VDD.t5 1.31934
R30 VDD.n1 VDD.t2 1.31934
R31 VDD.n1 VDD.t1 1.31934
R32 VDD.n3 VDD.n2 0.2405
R33 VDD.n4 VDD.n3 0.2405
R34 VDD VDD.n4 0.0485
R35 B.n0 B.t1 27.5107
R36 B.n0 B.t0 22.5169
R37 B B.n0 8.02014
R38 A.n0 A.t1 27.2902
R39 A.n0 A.t0 22.7374
R40 A A.n0 8.09156
R41 VNW.t2 VNW.t3 310.079
R42 VNW.t1 VNW.t2 310.079
R43 VNW.t0 VNW.t1 310.079
R44 VNW.t4 VNW.t0 310.079
R45 VNW.t5 VNW.t4 310.079
R46 VNW VNW.t5 259.69
R47 VPW.t2 VPW.t3 1181.82
R48 VPW.t1 VPW.t2 1181.82
R49 VPW.t0 VPW.t1 1181.82
R50 VPW.t4 VPW.t0 1181.82
R51 VPW.t5 VPW.t4 1181.82
R52 VPW VPW.t5 989.774
C0 VSS VNW 0.0057f
C1 Y a_28_68# 0.36498f
C2 B VSS 0.01447f
C3 a_28_68# a_172_68# 0.01319f
C4 A VSS 0.01271f
C5 VDD VSS 0.03611f
C6 Y VNW 0.05154f
C7 Y B 0
C8 Y A 0
C9 Y VDD 0.60631f
C10 B a_172_68# 0
C11 VDD a_172_68# 0
C12 a_28_68# VNW 0.36763f
C13 a_28_68# B 0.43668f
C14 a_28_68# A 0.10005f
C15 a_28_68# VDD 0.26183f
C16 B VNW 0.07769f
C17 A VNW 0.08344f
C18 Y VSS 0.30865f
C19 VDD VNW 0.18711f
C20 A B 0.08818f
C21 VSS a_172_68# 0.00814f
C22 B VDD 0.01873f
C23 A VDD 0.04399f
C24 a_28_68# VSS 0.30112f
C25 VSS VPW 0.49822f
C26 Y VPW 0.04981f
C27 VDD VPW 0.32397f
C28 B VPW 0.30179f
C29 A VPW 0.20993f
C30 VNW VPW 2.09756f
C31 a_28_68# VPW 0.48146f
C32 VNW.t3 VPW 0.20465f
C33 VNW.t2 VPW 0.09574f
C34 VNW.t1 VPW 0.09574f
C35 VNW.t0 VPW 0.09574f
C36 VNW.t4 VPW 0.09574f
C37 VNW.t5 VPW 0.08796f
C38 A.t1 VPW 0.08284f
C39 A.t0 VPW 0.06029f
C40 A.n0 VPW 0.10421f
C41 B.t1 VPW 0.14554f
C42 B.t0 VPW 0.10474f
C43 B.n0 VPW 0.18153f
C44 VDD.t4 VPW 0.08009f
C45 VDD.t0 VPW 0.02922f
C46 VDD.t5 VPW 0.02922f
C47 VDD.n0 VPW 0.05861f
C48 VDD.t2 VPW 0.02922f
C49 VDD.t1 VPW 0.02922f
C50 VDD.n1 VPW 0.0643f
C51 VDD.t3 VPW 0.11131f
C52 VDD.n2 VPW 0.4093f
C53 VDD.n3 VPW 0.17081f
C54 VDD.n4 VPW 0.12724f
C55 Y.t1 VPW 0.05517f
C56 Y.t0 VPW 0.05517f
C57 Y.n0 VPW 0.11886f
C58 Y.t4 VPW 0.03998f
C59 Y.t3 VPW 0.03998f
C60 Y.n1 VPW 0.08111f
C61 Y.n2 VPW 0.20941f
C62 Y.t7 VPW 0.05517f
C63 Y.t2 VPW 0.05517f
C64 Y.n3 VPW 0.12093f
C65 Y.n4 VPW 0.27635f
C66 Y.t6 VPW 0.03998f
C67 Y.t5 VPW 0.03998f
C68 Y.n5 VPW 0.07995f
C69 Y.n6 VPW 0.05375f
C70 VSS.t1 VPW 0.01589f
C71 VSS.t4 VPW 0.01589f
C72 VSS.n0 VPW 0.03189f
C73 VSS.t2 VPW 0.01589f
C74 VSS.t3 VPW 0.01589f
C75 VSS.n1 VPW 0.03334f
C76 VSS.t0 VPW 0.06217f
C77 VSS.n2 VPW 0.28555f
C78 VSS.n3 VPW 0.13996f
.ends

* NGSPICE file created from gf180mcu_as_sc_mcu7t3v3__ao211_2.ext - technology: gf180mcuD

.subckt gf180mcu_as_sc_mcu7t3v3__ao211_2 VDD VNW VPW VSS A B C D Y
X0 a_28_440# B.t1 VDD.t0 VNW.t4 pfet_03v3 ad=0.3588p pd=1.9u as=0.3588p ps=1.9u w=1.38u l=0.28u
X1 a_172_68# A.t0 VSS.t3 VPW.t5 nfet_03v3 ad=0.26p pd=1.52u as=0.44p ps=2.88u w=1u l=0.28u
X2 VDD.t2 a_332_68# Y.t0 VNW.t1 pfet_03v3 ad=0.7176p pd=3.8u as=0.3588p ps=1.9u w=1.38u l=0.28u
X3 VSS.t1 a_332_68# Y.t3 VPW.t1 nfet_03v3 ad=0.52p pd=3.04u as=0.26p ps=1.52u w=1u l=0.28u
X4 a_492_440# C.t1 a_28_440# VNW.t3 pfet_03v3 ad=0.3588p pd=1.9u as=0.3588p ps=1.9u w=1.38u l=0.28u
X5 a_332_68# D.t0 VSS.t2 VPW.t2 nfet_03v3 ad=0.44p pd=2.88u as=0.26p ps=1.52u w=1u l=0.28u
X6 a_332_68# D.t1 a_492_440# VNW.t2 pfet_03v3 ad=0.6072p pd=3.64u as=0.3588p ps=1.9u w=1.38u l=0.28u
X7 Y.t1 a_332_68# VDD.t1 VNW.t0 pfet_03v3 ad=0.3588p pd=1.9u as=0.6072p ps=3.64u w=1.38u l=0.28u
X8 Y.t2 a_332_68# VSS.t0 VPW.t0 nfet_03v3 ad=0.26p pd=1.52u as=0.44p ps=2.88u w=1u l=0.28u
X9 VSS.t4 C.t0 a_332_68# VPW.t3 nfet_03v3 ad=0.26p pd=1.52u as=0.26p ps=1.52u w=1u l=0.28u
X10 VDD.t3 A.t1 a_28_440# VNW.t5 pfet_03v3 ad=0.3588p pd=1.9u as=0.6072p ps=3.64u w=1.38u l=0.28u
X11 a_332_68# B.t0 a_172_68# VPW.t4 nfet_03v3 ad=0.26p pd=1.52u as=0.26p ps=1.52u w=1u l=0.28u
R0 VSS.n1 VSS.t0 10.9684
R1 VSS.n3 VSS.t3 10.8988
R2 VSS.n1 VSS.t1 10.5035
R3 VSS.n2 VSS.n0 6.39441
R4 VSS.n0 VSS.t2 1.6385
R5 VSS.n0 VSS.t4 1.6385
R6 VSS.n3 VSS.n2 0.3605
R7 VSS.n2 VSS.n1 0.2165
R8 VSS VSS.n3 0.0485
R9 Y.n2 Y.n1 6.3005
R10 Y.n2 Y.n0 3.09695
R11 Y.n1 Y.t3 1.6385
R12 Y.n1 Y.t2 1.6385
R13 Y.n0 Y.t0 1.31934
R14 Y.n0 Y.t1 1.31934
R15 Y Y.n2 0.0730806
R16 VDD.n2 VDD.n0 5.30224
R17 VDD.n1 VDD.t2 4.40391
R18 VDD.n1 VDD.t1 3.33441
R19 VDD.n0 VDD.t0 1.31934
R20 VDD.n0 VDD.t3 1.31934
R21 VDD.n2 VDD.n1 0.4565
R22 VDD VDD.n2 0.1685
R23 D.n0 D.t1 26.5024
R24 D.n0 D.t0 23.0798
R25 D D.n0 8.06128
R26 C.n0 C.t1 27.0693
R27 C.n0 C.t0 22.5129
R28 C C.n0 8.04842
R29 B.n0 B.t1 27.1997
R30 B.n0 B.t0 22.3825
R31 B B.n0 8.1057
R32 A.n0 A.t1 26.618
R33 A.n0 A.t0 21.5414
R34 A A.n0 8.05193
R35 VNW.t2 VNW.t0 558.14
R36 VNW.t0 VNW.t1 310.079
R37 VNW.t3 VNW.t2 310.079
R38 VNW.t4 VNW.t3 310.079
R39 VNW.t5 VNW.t4 310.079
R40 VNW VNW.t5 259.69
R41 VPW.t2 VPW.t0 2127.27
R42 VPW.t0 VPW.t1 1181.82
R43 VPW.t3 VPW.t2 1181.82
R44 VPW.t4 VPW.t3 1181.82
R45 VPW.t5 VPW.t4 1181.82
R46 VPW VPW.t5 989.774
C0 a_332_68# Y 0.14623f
C1 a_332_68# D 0.24708f
C2 B A 0.1065f
C3 VNW a_28_440# 0.01588f
C4 a_332_68# VSS 0.29425f
C5 C a_492_440# 0
C6 Y VSS 0.04557f
C7 a_332_68# VDD 0.33063f
C8 VSS D 0.01781f
C9 A a_28_440# 0.05839f
C10 Y VDD 0.26252f
C11 D VDD 0.02927f
C12 VSS VDD 0.02965f
C13 VSS a_172_68# 0.01004f
C14 a_332_68# VNW 0.22774f
C15 Y VNW 0.01231f
C16 VNW D 0.08458f
C17 a_332_68# A 0
C18 VSS VNW 0.00739f
C19 A D 0
C20 a_28_440# a_492_440# 0.00324f
C21 VNW VDD 0.19008f
C22 VSS A 0.03755f
C23 B C 0.11544f
C24 A VDD 0.01522f
C25 a_332_68# a_492_440# 0.0124f
C26 C a_28_440# 0.0073f
C27 VNW A 0.09409f
C28 D a_492_440# 0.00373f
C29 a_492_440# VDD 0.01267f
C30 a_332_68# C 0.06824f
C31 B a_28_440# 0.0527f
C32 C D 0.11359f
C33 VSS C 0.01519f
C34 C VDD 0.02827f
C35 A a_492_440# 0
C36 B a_332_68# 0.11634f
C37 B Y 0
C38 B D 0.0022f
C39 VNW C 0.07741f
C40 B VSS 0.08953f
C41 a_332_68# a_28_440# 0.02741f
C42 A C 0
C43 B VDD 0.0166f
C44 a_28_440# D 0.00192f
C45 B a_172_68# 0.00862f
C46 VSS a_28_440# 0.01667f
C47 a_28_440# VDD 0.2046f
C48 a_28_440# a_172_68# 0.00272f
C49 B VNW 0.07746f
C50 VSS VPW 0.45701f
C51 Y VPW 0.05876f
C52 VDD VPW 0.37885f
C53 D VPW 0.22361f
C54 C VPW 0.19002f
C55 B VPW 0.18056f
C56 A VPW 0.21857f
C57 VNW VPW 2.26475f
C58 a_28_440# VPW 0.01738f
C59 a_332_68# VPW 0.26837f
C60 VNW.t1 VPW 0.18272f
C61 VNW.t0 VPW 0.12555f
C62 VNW.t2 VPW 0.12555f
C63 VNW.t3 VPW 0.08968f
C64 VNW.t4 VPW 0.08968f
C65 VNW.t5 VPW 0.08239f
C66 A.t1 VPW 0.07471f
C67 A.t0 VPW 0.05357f
C68 A.n0 VPW 0.11093f
C69 B.t1 VPW 0.17202f
C70 B.t0 VPW 0.12381f
C71 B.n0 VPW 0.22458f
C72 C.t1 VPW 0.1074f
C73 C.t0 VPW 0.07775f
C74 C.n0 VPW 0.13971f
C75 D.t1 VPW 0.12214f
C76 D.t0 VPW 0.09052f
C77 D.n0 VPW 0.1607f
C78 VDD.t0 VPW 0.0313f
C79 VDD.t3 VPW 0.0313f
C80 VDD.n0 VPW 0.06283f
C81 VDD.t1 VPW 0.0798f
C82 VDD.t2 VPW 0.10834f
C83 VDD.n1 VPW 0.51257f
C84 VDD.n2 VPW 0.23475f
C85 Y.t0 VPW 0.04128f
C86 Y.t1 VPW 0.04128f
C87 Y.n0 VPW 0.09908f
C88 Y.t3 VPW 0.02991f
C89 Y.t2 VPW 0.02991f
C90 Y.n1 VPW 0.05982f
C91 Y.n2 VPW 0.15644f
C92 VSS.t3 VPW 0.03546f
C93 VSS.t2 VPW 0.01219f
C94 VSS.t4 VPW 0.01219f
C95 VSS.n0 VPW 0.02448f
C96 VSS.t0 VPW 0.03545f
C97 VSS.t1 VPW 0.04445f
C98 VSS.n1 VPW 0.18168f
C99 VSS.n2 VPW 0.11719f
C100 VSS.n3 VPW 0.09157f
.ends

* NGSPICE file created from gf180mcu_as_sc_mcu7t3v3__ao211_4.ext - technology: gf180mcuD

.subckt gf180mcu_as_sc_mcu7t3v3__ao211_4 VDD VNW VPW VSS A B C D Y
X0 a_28_440# B.t1 VDD.t5 VNW.t6 pfet_03v3 ad=0.3588p pd=1.9u as=0.3588p ps=1.9u w=1.38u l=0.28u
X1 Y.t5 a_332_68# VSS.t6 VPW.t3 nfet_03v3 ad=0.26p pd=1.52u as=0.26p ps=1.52u w=1u l=0.28u
X2 a_172_68# A.t0 VSS.t0 VPW.t7 nfet_03v3 ad=0.26p pd=1.52u as=0.44p ps=2.88u w=1u l=0.28u
X3 VDD.t2 a_332_68# Y.t2 VNW.t2 pfet_03v3 ad=0.3588p pd=1.9u as=0.3588p ps=1.9u w=1.38u l=0.28u
X4 VSS.t3 a_332_68# Y.t4 VPW.t2 nfet_03v3 ad=0.26p pd=1.52u as=0.26p ps=1.52u w=1u l=0.28u
X5 a_492_440# C.t1 a_28_440# VNW.t5 pfet_03v3 ad=0.3588p pd=1.9u as=0.3588p ps=1.9u w=1.38u l=0.28u
X6 a_332_68# D.t0 VSS.t1 VPW.t0 nfet_03v3 ad=0.44p pd=2.88u as=0.26p ps=1.52u w=1u l=0.28u
X7 Y.t0 a_332_68# VDD.t3 VNW.t3 pfet_03v3 ad=0.3588p pd=1.9u as=0.3588p ps=1.9u w=1.38u l=0.28u
X8 a_332_68# D.t1 a_492_440# VNW.t0 pfet_03v3 ad=0.6072p pd=3.64u as=0.3588p ps=1.9u w=1.38u l=0.28u
X9 Y.t7 a_332_68# VDD.t1 VNW.t1 pfet_03v3 ad=0.3588p pd=1.9u as=0.6072p ps=3.64u w=1.38u l=0.28u
X10 Y.t3 a_332_68# VSS.t4 VPW.t1 nfet_03v3 ad=0.26p pd=1.52u as=0.44p ps=2.88u w=1u l=0.28u
X11 VSS.t2 C.t0 a_332_68# VPW.t5 nfet_03v3 ad=0.26p pd=1.52u as=0.26p ps=1.52u w=1u l=0.28u
X12 VDD.t4 a_332_68# Y.t1 VNW.t4 pfet_03v3 ad=0.828p pd=3.96u as=0.3588p ps=1.9u w=1.38u l=0.28u
X13 VDD.t0 A.t1 a_28_440# VNW.t7 pfet_03v3 ad=0.3588p pd=1.9u as=0.6072p ps=3.64u w=1.38u l=0.28u
X14 VSS.t5 a_332_68# Y.t6 VPW.t4 nfet_03v3 ad=0.6p pd=3.2u as=0.26p ps=1.52u w=1u l=0.28u
X15 a_332_68# B.t0 a_172_68# VPW.t6 nfet_03v3 ad=0.26p pd=1.52u as=0.26p ps=1.52u w=1u l=0.28u
R0 VSS.n3 VSS.t4 10.9684
R1 VSS.n5 VSS.t0 10.8988
R2 VSS.n2 VSS.t5 9.98659
R3 VSS.n4 VSS.n0 6.39441
R4 VSS.n2 VSS.n1 6.38659
R5 VSS.n1 VSS.t6 1.6385
R6 VSS.n1 VSS.t3 1.6385
R7 VSS.n0 VSS.t1 1.6385
R8 VSS.n0 VSS.t2 1.6385
R9 VSS.n5 VSS.n4 0.3605
R10 VSS.n3 VSS.n2 0.2405
R11 VSS.n4 VSS.n3 0.2165
R12 VSS VSS.n5 0.0485
R13 Y.n2 Y.n1 6.3005
R14 Y.n5 Y.n4 6.3005
R15 Y.n6 Y.n3 2.85163
R16 Y.n7 Y.n0 2.85163
R17 Y.n4 Y.t6 1.6385
R18 Y.n4 Y.t5 1.6385
R19 Y.n1 Y.t4 1.6385
R20 Y.n1 Y.t3 1.6385
R21 Y.n3 Y.t1 1.31934
R22 Y.n3 Y.t0 1.31934
R23 Y.n0 Y.t2 1.31934
R24 Y.n0 Y.t7 1.31934
R25 Y.n7 Y 0.388709
R26 Y.n6 Y 0.318403
R27 Y.n7 Y 0.318403
R28 Y.n7 Y.n2 0.148565
R29 Y.n6 Y.n5 0.148565
R30 Y.n2 Y 0.0730806
R31 Y.n5 Y 0.0730806
R32 Y Y.n6 0.0421418
R33 Y Y.n7 0.0421418
R34 VDD.n4 VDD.n0 5.30224
R35 VDD.n2 VDD.t4 4.44304
R36 VDD.n3 VDD.t1 3.33441
R37 VDD.n2 VDD.n1 2.8842
R38 VDD.n0 VDD.t5 1.31934
R39 VDD.n0 VDD.t0 1.31934
R40 VDD.n1 VDD.t3 1.31934
R41 VDD.n1 VDD.t2 1.31934
R42 VDD.n4 VDD.n3 0.4565
R43 VDD.n3 VDD.n2 0.2405
R44 VDD VDD.n4 0.1685
R45 D.n0 D.t1 26.5024
R46 D.n0 D.t0 23.0798
R47 D D.n0 8.06128
R48 C.n0 C.t1 27.0693
R49 C.n0 C.t0 22.5129
R50 C C.n0 8.04842
R51 B.n0 B.t1 27.1997
R52 B.n0 B.t0 22.3825
R53 B B.n0 8.1057
R54 A.n0 A.t1 26.618
R55 A.n0 A.t0 21.5414
R56 A A.n0 8.05193
R57 VNW.t0 VNW.t1 558.14
R58 VNW.t3 VNW.t4 310.079
R59 VNW.t2 VNW.t3 310.079
R60 VNW.t1 VNW.t2 310.079
R61 VNW.t5 VNW.t0 310.079
R62 VNW.t6 VNW.t5 310.079
R63 VNW.t7 VNW.t6 310.079
R64 VNW VNW.t7 259.69
R65 VPW.t0 VPW.t1 2127.27
R66 VPW.t3 VPW.t4 1181.82
R67 VPW.t2 VPW.t3 1181.82
R68 VPW.t1 VPW.t2 1181.82
R69 VPW.t5 VPW.t0 1181.82
R70 VPW.t6 VPW.t5 1181.82
R71 VPW.t7 VPW.t6 1181.82
R72 VPW VPW.t7 989.774
C0 VSS a_332_68# 0.33486f
C1 Y B 0
C2 VNW VSS 0.00766f
C3 Y VDD 0.62258f
C4 VNW a_332_68# 0.40366f
C5 a_172_68# VSS 0.01004f
C6 C VSS 0.01519f
C7 VSS B 0.08954f
C8 C a_332_68# 0.06824f
C9 VSS A 0.03755f
C10 D VSS 0.01781f
C11 VDD VSS 0.03207f
C12 VNW C 0.07741f
C13 a_332_68# B 0.11634f
C14 VSS a_28_440# 0.01667f
C15 VNW B 0.07746f
C16 A a_332_68# 0
C17 D a_332_68# 0.24708f
C18 VDD a_332_68# 0.38851f
C19 VNW A 0.09409f
C20 VNW D 0.08458f
C21 a_332_68# a_28_440# 0.02741f
C22 VNW VDD 0.24738f
C23 VNW a_28_440# 0.01588f
C24 a_172_68# B 0.00862f
C25 C B 0.11544f
C26 C A 0
C27 C D 0.11359f
C28 C VDD 0.02827f
C29 a_172_68# a_28_440# 0.00272f
C30 A B 0.1065f
C31 D B 0.0022f
C32 C a_28_440# 0.0073f
C33 a_492_440# a_332_68# 0.0124f
C34 VDD B 0.0166f
C35 B a_28_440# 0.0527f
C36 D A 0
C37 VDD A 0.01522f
C38 D VDD 0.02927f
C39 A a_28_440# 0.05839f
C40 D a_28_440# 0.00192f
C41 VDD a_28_440# 0.2046f
C42 C a_492_440# 0
C43 a_492_440# A 0
C44 a_492_440# D 0.00373f
C45 a_492_440# VDD 0.01267f
C46 a_492_440# a_28_440# 0.00324f
C47 Y VSS 0.14254f
C48 Y a_332_68# 0.26311f
C49 Y VNW 0.02113f
C50 VSS VPW 0.55292f
C51 Y VPW 0.06155f
C52 VDD VPW 0.45046f
C53 D VPW 0.22361f
C54 C VPW 0.19002f
C55 B VPW 0.18055f
C56 A VPW 0.21857f
C57 VNW VPW 2.78994f
C58 a_28_440# VPW 0.01738f
C59 a_332_68# VPW 0.48026f
C60 VNW.t4 VPW 0.2023f
C61 VNW.t3 VPW 0.09464f
C62 VNW.t2 VPW 0.09464f
C63 VNW.t1 VPW 0.1325f
C64 VNW.t0 VPW 0.1325f
C65 VNW.t5 VPW 0.09464f
C66 VNW.t6 VPW 0.09464f
C67 VNW.t7 VPW 0.08695f
C68 A.t1 VPW 0.07471f
C69 A.t0 VPW 0.05357f
C70 A.n0 VPW 0.11093f
C71 B.t1 VPW 0.17203f
C72 B.t0 VPW 0.12382f
C73 B.n0 VPW 0.22458f
C74 C.t1 VPW 0.1074f
C75 C.t0 VPW 0.07775f
C76 C.n0 VPW 0.13971f
C77 D.t1 VPW 0.12214f
C78 D.t0 VPW 0.09052f
C79 D.n0 VPW 0.1607f
C80 VDD.t5 VPW 0.03327f
C81 VDD.t0 VPW 0.03327f
C82 VDD.n0 VPW 0.06679f
C83 VDD.t1 VPW 0.08483f
C84 VDD.t3 VPW 0.03327f
C85 VDD.t2 VPW 0.03327f
C86 VDD.n1 VPW 0.07073f
C87 VDD.t4 VPW 0.1314f
C88 VDD.n2 VPW 0.45449f
C89 VDD.n3 VPW 0.34396f
C90 VDD.n4 VPW 0.24956f
C91 Y.t2 VPW 0.04194f
C92 Y.t7 VPW 0.04194f
C93 Y.n0 VPW 0.09042f
C94 Y.t4 VPW 0.03039f
C95 Y.t3 VPW 0.03039f
C96 Y.n1 VPW 0.06079f
C97 Y.n2 VPW 0.02754f
C98 Y.t1 VPW 0.04194f
C99 Y.t0 VPW 0.04194f
C100 Y.n3 VPW 0.09042f
C101 Y.t6 VPW 0.03039f
C102 Y.t5 VPW 0.03039f
C103 Y.n4 VPW 0.06079f
C104 Y.n5 VPW 0.02754f
C105 Y.n6 VPW 0.1753f
C106 Y.n7 VPW 0.21975f
C107 VSS.t0 VPW 0.03449f
C108 VSS.t1 VPW 0.01186f
C109 VSS.t2 VPW 0.01186f
C110 VSS.n0 VPW 0.02381f
C111 VSS.t4 VPW 0.03448f
C112 VSS.t6 VPW 0.01186f
C113 VSS.t3 VPW 0.01186f
C114 VSS.n1 VPW 0.0238f
C115 VSS.t5 VPW 0.05042f
C116 VSS.n2 VPW 0.17985f
C117 VSS.n3 VPW 0.09784f
C118 VSS.n4 VPW 0.11399f
C119 VSS.n5 VPW 0.08907f
.ends

* NGSPICE file created from gf180mcu_as_sc_mcu7t3v3__ao21_2.ext - technology: gf180mcuD

.subckt gf180mcu_as_sc_mcu7t3v3__ao21_2 VDD VNW VPW VSS Y A B C
X0 VSS.t0 a_332_68# Y.t3 VPW.t1 nfet_03v3 ad=0.44p pd=2.88u as=0.3025p ps=1.605u w=1u l=0.28u
X1 a_28_440# B.t1 VDD.t2 VNW.t3 pfet_03v3 ad=0.3588p pd=1.9u as=0.3588p ps=1.9u w=1.38u l=0.28u
X2 a_172_68# A.t0 VSS.t2 VPW.t4 nfet_03v3 ad=0.26p pd=1.52u as=0.44p ps=2.88u w=1u l=0.28u
X3 a_332_68# C.t1 a_28_440# VNW.t2 pfet_03v3 ad=0.6072p pd=3.64u as=0.3588p ps=1.9u w=1.38u l=0.28u
X4 Y.t0 a_332_68# VDD.t0 VNW.t0 pfet_03v3 ad=0.41745p pd=1.985u as=0.6072p ps=3.64u w=1.38u l=0.28u
X5 VSS.t3 C.t0 a_332_68# VPW.t2 nfet_03v3 ad=0.58p pd=2.16u as=0.26p ps=1.52u w=1u l=0.28u
X6 Y.t2 a_332_68# VSS.t1 VPW.t0 nfet_03v3 ad=0.3025p pd=1.605u as=0.58p ps=2.16u w=1u l=0.28u
X7 VDD.t1 a_332_68# Y.t1 VNW.t1 pfet_03v3 ad=0.6072p pd=3.64u as=0.41745p ps=1.985u w=1.38u l=0.28u
X8 VDD.t3 A.t1 a_28_440# VNW.t4 pfet_03v3 ad=0.3588p pd=1.9u as=0.6072p ps=3.64u w=1.38u l=0.28u
X9 a_332_68# B.t0 a_172_68# VPW.t3 nfet_03v3 ad=0.26p pd=1.52u as=0.26p ps=1.52u w=1u l=0.28u
R0 VSS.n3 VSS.t2 10.9684
R1 VSS.n0 VSS.t0 5.2353
R2 VSS.n1 VSS.t1 3.6545
R3 VSS.n1 VSS.t3 3.6545
R4 VSS.n2 VSS.n1 3.1505
R5 VSS.n0 VSS 0.52175
R6 VSS.n4 VSS.n3 0.34325
R7 VSS VSS.n4 0.237318
R8 VSS.n3 VSS 0.0485
R9 VSS.n2 VSS.n0 0.0400455
R10 VSS.n4 VSS.n2 0.0400455
R11 Y.n2 Y.n1 6.3005
R12 Y.n2 Y.n0 3.06034
R13 Y.n1 Y.t2 2.174
R14 Y.n0 Y.t0 1.7505
R15 Y.n1 Y.t3 1.6385
R16 Y.n0 Y.t1 1.31934
R17 Y Y.n2 0.0483125
R18 VDD.n2 VDD.n0 5.28659
R19 VDD.n1 VDD.t1 3.59108
R20 VDD.n1 VDD.t0 3.33833
R21 VDD.n0 VDD.t2 1.31934
R22 VDD.n0 VDD.t3 1.31934
R23 VDD.n2 VDD.n1 0.3365
R24 VDD VDD.n2 0.1685
R25 C.n0 C.t1 27.0524
R26 C.n0 C.t0 22.4673
R27 C C.n0 8.05427
R28 B.n0 B.t1 27.2111
R29 B.n0 B.t0 22.3086
R30 B B.n0 8.0566
R31 A.n0 A.t1 27.2905
R32 A.n0 A.t0 22.2292
R33 A A.n0 8.02646
R34 VNW.t2 VNW.t0 558.14
R35 VNW.t0 VNW.t1 343.024
R36 VNW.t3 VNW.t2 310.079
R37 VNW.t4 VNW.t3 310.079
R38 VNW VNW.t4 259.69
R39 VPW.t2 VPW.t0 2127.27
R40 VPW.t0 VPW.t1 1307.39
R41 VPW.t3 VPW.t2 1181.82
R42 VPW.t4 VPW.t3 1181.82
R43 VPW VPW.t4 989.774
C0 VNW A 0.09208f
C1 a_28_440# VSS 0.01381f
C2 Y VNW 0.0216f
C3 a_172_68# VSS 0.01248f
C4 a_28_440# A 0.07442f
C5 C VSS 0.01669f
C6 C A 0.00104f
C7 Y a_172_68# 0
C8 Y C 0
C9 VDD VSS 0.0337f
C10 a_332_68# VSS 0.21926f
C11 a_28_440# VNW 0.01143f
C12 VDD A 0.01567f
C13 a_332_68# A 0.01174f
C14 B VSS 0.03227f
C15 C VNW 0.08383f
C16 Y VDD 0.28885f
C17 Y a_332_68# 0.1365f
C18 B A 0.09244f
C19 a_172_68# a_28_440# 0.00248f
C20 C a_28_440# 0.0081f
C21 Y B 0
C22 VDD VNW 0.19581f
C23 a_332_68# VNW 0.23775f
C24 B VNW 0.07586f
C25 a_28_440# VDD 0.19178f
C26 a_332_68# a_28_440# 0.04896f
C27 a_172_68# a_332_68# 0.00221f
C28 C VDD 0.02901f
C29 C a_332_68# 0.19083f
C30 B a_28_440# 0.04153f
C31 a_172_68# B 0.0025f
C32 B C 0.09012f
C33 VSS A 0.03614f
C34 a_332_68# VDD 0.35316f
C35 Y VSS 0.07945f
C36 B VDD 0.01624f
C37 B a_332_68# 0.00698f
C38 Y A 0
C39 VSS VNW 0.00986f
C40 VSS VPW 0.27542f
C41 Y VPW 0.03486f
C42 VDD VPW 0.36792f
C43 C VPW 0.17008f
C44 B VPW 0.15167f
C45 A VPW 0.23473f
C46 VNW VPW 2.09189f
C47 a_28_440# VPW 0.01714f
C48 a_332_68# VPW 0.26835f
C49 VNW.t1 VPW 0.20601f
C50 VNW.t0 VPW 0.13105f
C51 VNW.t2 VPW 0.12626f
C52 VNW.t3 VPW 0.09018f
C53 VNW.t4 VPW 0.08285f
C54 A.t1 VPW 0.07514f
C55 A.t0 VPW 0.05373f
C56 A.n0 VPW 0.09913f
C57 B.t1 VPW 0.09759f
C58 B.t0 VPW 0.07014f
C59 B.n0 VPW 0.12901f
C60 C.t1 VPW 0.11395f
C61 C.t0 VPW 0.08273f
C62 C.n0 VPW 0.15122f
C63 VDD.t2 VPW 0.03328f
C64 VDD.t3 VPW 0.03328f
C65 VDD.n0 VPW 0.06675f
C66 VDD.t0 VPW 0.08534f
C67 VDD.t1 VPW 0.10264f
C68 VDD.n1 VPW 0.53715f
C69 VDD.n2 VPW 0.20344f
C70 Y.t1 VPW 0.04284f
C71 Y.t0 VPW 0.05685f
C72 Y.n0 VPW 0.1158f
C73 Y.t3 VPW 0.03105f
C74 Y.t2 VPW 0.0412f
C75 Y.n1 VPW 0.07224f
C76 Y.n2 VPW 0.16004f
C77 VSS.t0 VPW 0.0297f
C78 VSS.n0 VPW 0.21075f
C79 VSS.t1 VPW 0.02165f
C80 VSS.t3 VPW 0.02165f
C81 VSS.n1 VPW 0.04329f
C82 VSS.n2 VPW 0.03215f
C83 VSS.t2 VPW 0.02822f
C84 VSS.n3 VPW 0.06966f
C85 VSS.n4 VPW 0.1635f
.ends

* NGSPICE file created from gf180mcu_as_sc_mcu7t3v3__ao21_4.ext - technology: gf180mcuD

.subckt gf180mcu_as_sc_mcu7t3v3__ao21_4 VDD VNW VPW VSS Y A B C
X0 VSS.t3 a_332_68# Y.t5 VPW.t1 nfet_03v3 ad=0.26p pd=1.52u as=0.3025p ps=1.605u w=1u l=0.28u
X1 a_28_440# B.t1 VDD.t0 VNW.t5 pfet_03v3 ad=0.3588p pd=1.9u as=0.3588p ps=1.9u w=1.38u l=0.28u
X2 Y.t1 a_332_68# VDD.t4 VNW.t2 pfet_03v3 ad=0.3588p pd=1.9u as=0.3588p ps=1.9u w=1.38u l=0.28u
X3 a_172_68# A.t0 VSS.t0 VPW.t6 nfet_03v3 ad=0.26p pd=1.52u as=0.44p ps=2.88u w=1u l=0.28u
X4 a_332_68# C.t1 a_28_440# VNW.t4 pfet_03v3 ad=0.6072p pd=3.64u as=0.3588p ps=1.9u w=1.38u l=0.28u
X5 Y.t3 a_332_68# VDD.t2 VNW.t0 pfet_03v3 ad=0.41745p pd=1.985u as=0.6072p ps=3.64u w=1.38u l=0.28u
X6 VDD.t5 a_332_68# Y.t2 VNW.t3 pfet_03v3 ad=0.6279p pd=3.67u as=0.3588p ps=1.9u w=1.38u l=0.28u
X7 VSS.t4 a_332_68# Y.t7 VPW.t3 nfet_03v3 ad=0.455p pd=2.91u as=0.26p ps=1.52u w=1u l=0.28u
X8 VSS.t1 C.t0 a_332_68# VPW.t4 nfet_03v3 ad=0.58p pd=2.16u as=0.26p ps=1.52u w=1u l=0.28u
X9 Y.t6 a_332_68# VSS.t5 VPW.t2 nfet_03v3 ad=0.26p pd=1.52u as=0.26p ps=1.52u w=1u l=0.28u
X10 Y.t4 a_332_68# VSS.t2 VPW.t0 nfet_03v3 ad=0.3025p pd=1.605u as=0.58p ps=2.16u w=1u l=0.28u
X11 VDD.t3 a_332_68# Y.t0 VNW.t1 pfet_03v3 ad=0.3588p pd=1.9u as=0.41745p ps=1.985u w=1.38u l=0.28u
X12 VDD.t1 A.t1 a_28_440# VNW.t6 pfet_03v3 ad=0.3588p pd=1.9u as=0.6072p ps=3.64u w=1.38u l=0.28u
X13 a_332_68# B.t0 a_172_68# VPW.t5 nfet_03v3 ad=0.26p pd=1.52u as=0.26p ps=1.52u w=1u l=0.28u
R0 VSS.n5 VSS.t0 10.9684
R1 VSS.n1 VSS.t4 5.2398
R2 VSS.n3 VSS.t2 3.6545
R3 VSS.n3 VSS.t1 3.6545
R4 VSS.n1 VSS.n0 3.3618
R5 VSS.n4 VSS.n3 3.1505
R6 VSS.n0 VSS.t5 1.6385
R7 VSS.n0 VSS.t3 1.6385
R8 VSS.n2 VSS 0.52175
R9 VSS.n6 VSS.n5 0.34325
R10 VSS VSS.n6 0.237318
R11 VSS.n2 VSS.n1 0.236
R12 VSS.n5 VSS 0.0485
R13 VSS.n4 VSS.n2 0.0400455
R14 VSS.n6 VSS.n4 0.0400455
R15 Y.n2 Y.n1 6.47347
R16 Y.n6 Y.n5 6.3005
R17 Y.n2 Y.n0 2.88737
R18 Y.n4 Y.n3 2.88737
R19 Y.n5 Y.t4 2.174
R20 Y.n3 Y.t3 1.7505
R21 Y.n5 Y.t5 1.6385
R22 Y.n1 Y.t7 1.6385
R23 Y.n1 Y.t6 1.6385
R24 Y.n3 Y.t0 1.31934
R25 Y.n0 Y.t2 1.31934
R26 Y.n0 Y.t1 1.31934
R27 Y.n4 Y.n2 0.50137
R28 Y.n6 Y.n4 0.173469
R29 Y Y.n6 0.0483125
R30 VDD.n4 VDD.n0 5.28659
R31 VDD.n2 VDD.t5 3.57833
R32 VDD.n3 VDD.t2 3.33833
R33 VDD.n2 VDD.n1 2.01949
R34 VDD.n0 VDD.t0 1.31934
R35 VDD.n0 VDD.t1 1.31934
R36 VDD.n1 VDD.t4 1.31934
R37 VDD.n1 VDD.t3 1.31934
R38 VDD.n4 VDD.n3 0.3365
R39 VDD.n3 VDD.n2 0.25325
R40 VDD VDD.n4 0.1685
R41 C.n0 C.t1 27.0524
R42 C.n0 C.t0 22.4673
R43 C C.n0 8.05427
R44 B.n0 B.t1 27.2111
R45 B.n0 B.t0 22.3086
R46 B B.n0 8.0566
R47 A.n0 A.t1 27.2905
R48 A.n0 A.t0 22.2292
R49 A A.n0 8.02646
R50 VNW.t4 VNW.t0 558.14
R51 VNW.t0 VNW.t1 343.024
R52 VNW.t2 VNW.t3 310.079
R53 VNW.t1 VNW.t2 310.079
R54 VNW.t5 VNW.t4 310.079
R55 VNW.t6 VNW.t5 310.079
R56 VNW VNW.t6 259.69
R57 VPW.t4 VPW.t0 2127.27
R58 VPW.t0 VPW.t1 1307.39
R59 VPW.t2 VPW.t3 1181.82
R60 VPW.t1 VPW.t2 1181.82
R61 VPW.t5 VPW.t4 1181.82
R62 VPW.t6 VPW.t5 1181.82
R63 VPW VPW.t6 989.774
C0 a_332_68# B 0.00698f
C1 VSS Y 0.26235f
C2 A VNW 0.09208f
C3 Y a_172_68# 0
C4 C a_28_440# 0.0081f
C5 VDD VNW 0.25399f
C6 Y B 0
C7 A a_28_440# 0.07442f
C8 a_332_68# VNW 0.4122f
C9 A C 0.00104f
C10 VSS a_172_68# 0.01248f
C11 VDD a_28_440# 0.19178f
C12 VDD C 0.02901f
C13 Y VNW 0.04365f
C14 VSS B 0.03227f
C15 a_332_68# a_28_440# 0.04896f
C16 a_172_68# B 0.0025f
C17 VDD A 0.01567f
C18 a_332_68# C 0.19083f
C19 a_332_68# A 0.01174f
C20 Y C 0
C21 VSS VNW 0.01054f
C22 a_332_68# VDD 0.41133f
C23 Y A 0
C24 VNW B 0.07586f
C25 Y VDD 0.66221f
C26 VSS a_28_440# 0.01381f
C27 a_172_68# a_28_440# 0.00248f
C28 VSS C 0.01669f
C29 a_332_68# Y 0.24255f
C30 B a_28_440# 0.04153f
C31 VSS A 0.03614f
C32 C B 0.09012f
C33 VSS VDD 0.03486f
C34 A B 0.09244f
C35 a_332_68# VSS 0.27526f
C36 VNW a_28_440# 0.01143f
C37 VDD B 0.01624f
C38 a_332_68# a_172_68# 0.00221f
C39 VNW C 0.08383f
C40 VSS VPW 0.34248f
C41 Y VPW 0.04452f
C42 VDD VPW 0.43437f
C43 C VPW 0.17008f
C44 B VPW 0.15167f
C45 A VPW 0.23473f
C46 VNW VPW 2.61862f
C47 a_28_440# VPW 0.01714f
C48 a_332_68# VPW 0.48147f
C49 VNW.t3 VPW 0.22535f
C50 VNW.t2 VPW 0.09667f
C51 VNW.t1 VPW 0.1018f
C52 VNW.t0 VPW 0.14047f
C53 VNW.t4 VPW 0.13533f
C54 VNW.t5 VPW 0.09667f
C55 VNW.t6 VPW 0.08881f
C56 A.t1 VPW 0.07514f
C57 A.t0 VPW 0.05373f
C58 A.n0 VPW 0.09913f
C59 B.t1 VPW 0.09759f
C60 B.t0 VPW 0.07014f
C61 B.n0 VPW 0.12901f
C62 C.t1 VPW 0.11395f
C63 C.t0 VPW 0.08273f
C64 C.n0 VPW 0.15122f
C65 VDD.t0 VPW 0.03557f
C66 VDD.t1 VPW 0.03557f
C67 VDD.n0 VPW 0.07135f
C68 VDD.t2 VPW 0.09121f
C69 VDD.t4 VPW 0.03557f
C70 VDD.t3 VPW 0.03557f
C71 VDD.n1 VPW 0.0783f
C72 VDD.t5 VPW 0.11172f
C73 VDD.n2 VPW 0.50625f
C74 VDD.n3 VPW 0.32991f
C75 VDD.n4 VPW 0.21744f
C76 Y.t2 VPW 0.04826f
C77 Y.t1 VPW 0.04826f
C78 Y.n0 VPW 0.10588f
C79 Y.t7 VPW 0.03497f
C80 Y.t6 VPW 0.03497f
C81 Y.n1 VPW 0.07104f
C82 Y.n2 VPW 0.23486f
C83 Y.t0 VPW 0.04826f
C84 Y.t3 VPW 0.06403f
C85 Y.n3 VPW 0.12166f
C86 Y.n4 VPW 0.19485f
C87 Y.t5 VPW 0.03497f
C88 Y.t4 VPW 0.0464f
C89 Y.n5 VPW 0.08137f
C90 Y.n6 VPW 0.03379f
C91 VSS.t5 VPW 0.01147f
C92 VSS.t3 VPW 0.01147f
C93 VSS.n0 VPW 0.02398f
C94 VSS.t4 VPW 0.03633f
C95 VSS.n1 VPW 0.20653f
C96 VSS.n2 VPW 0.15256f
C97 VSS.t2 VPW 0.02559f
C98 VSS.t1 VPW 0.02559f
C99 VSS.n3 VPW 0.05118f
C100 VSS.n4 VPW 0.038f
C101 VSS.t0 VPW 0.03336f
C102 VSS.n5 VPW 0.08235f
C103 VSS.n6 VPW 0.19329f
.ends

* NGSPICE file created from gf180mcu_as_sc_mcu7t3v3__ao21b_2.ext - technology: gf180mcuD

.subckt gf180mcu_as_sc_mcu7t3v3__ao21b_2 VDD VNW VPW VSS Y C B A
X0 a_364_440# C.t2 a_668_68# VNW.t3 pfet_03v3 ad=0.6072p pd=3.64u as=0.3588p ps=1.9u w=1.38u l=0.28u
X1 Y.t3 a_668_68# VDD.t5 VNW.t4 pfet_03v3 ad=0.3588p pd=1.9u as=0.6072p ps=3.64u w=1.38u l=0.28u
X2 VSS.t5 a_668_68# Y.t2 VPW.t5 nfet_03v3 ad=0.45p pd=2.9u as=0.26p ps=1.52u w=1u l=0.28u
X3 a_668_68# B.t1 a_508_68# VPW.t6 nfet_03v3 ad=0.26p pd=1.52u as=0.26p ps=1.52u w=1u l=0.28u
X4 VSS.t1 C.t0 a_668_68# VPW.t3 nfet_03v3 ad=0.58p pd=2.16u as=0.26p ps=1.52u w=1u l=0.28u
X5 a_220_68# A.t0 VSS.t0 VPW.t8 nfet_03v3 ad=0.44p pd=2.88u as=0.47p ps=2.94u w=1u l=0.28u
X6 Y.t1 a_668_68# VSS.t6 VPW.t4 nfet_03v3 ad=0.26p pd=1.52u as=0.58p ps=2.16u w=1u l=0.28u
X7 a_508_68# a_220_68# VSS.t3 VPW.t0 nfet_03v3 ad=0.26p pd=1.52u as=0.44p ps=2.88u w=1u l=0.28u
X8 a_220_68# A.t1 VDD.t2 VNW.t8 pfet_03v3 ad=0.6072p pd=3.64u as=0.6348p ps=3.68u w=1.38u l=0.28u
X9 VDD.t0 a_220_68# a_364_440# VNW.t0 pfet_03v3 ad=0.3588p pd=1.9u as=0.6072p ps=3.64u w=1.38u l=0.28u
X10 a_364_440# a_220_68# VDD.t1 VNW.t1 pfet_03v3 ad=0.3588p pd=1.9u as=0.3588p ps=1.9u w=1.38u l=0.28u
X11 a_668_68# C.t1 VSS.t4 VPW.t2 nfet_03v3 ad=0.26p pd=1.52u as=0.26p ps=1.52u w=1u l=0.28u
X12 VDD.t6 a_668_68# Y.t0 VNW.t5 pfet_03v3 ad=0.621p pd=3.66u as=0.3588p ps=1.9u w=1.38u l=0.28u
X13 a_668_68# C.t3 a_364_440# VNW.t2 pfet_03v3 ad=0.3588p pd=1.9u as=0.3588p ps=1.9u w=1.38u l=0.28u
X14 VSS.t2 a_220_68# a_828_68# VPW.t1 nfet_03v3 ad=0.26p pd=1.52u as=0.26p ps=1.52u w=1u l=0.28u
X15 a_364_440# B.t3 VDD.t4 VNW.t6 pfet_03v3 ad=0.3588p pd=1.9u as=0.3588p ps=1.9u w=1.38u l=0.28u
X16 a_828_68# B.t0 a_668_68# VPW.t7 nfet_03v3 ad=0.26p pd=1.52u as=0.26p ps=1.52u w=1u l=0.28u
X17 VDD.t3 B.t2 a_364_440# VNW.t7 pfet_03v3 ad=0.3588p pd=1.9u as=0.3588p ps=1.9u w=1.38u l=0.28u
R0 VSS.n0 VSS.t5 11.0901
R1 VSS.n5 VSS.t3 10.9684
R2 VSS.n4 VSS.t0 10.6759
R3 VSS.n6 VSS.n3 6.38659
R4 VSS.n1 VSS.t6 3.686
R5 VSS.n1 VSS.t1 3.623
R6 VSS.n2 VSS.n1 3.1505
R7 VSS.n3 VSS.t4 1.6385
R8 VSS.n3 VSS.t2 1.6385
R9 VSS.n0 VSS 1.133
R10 VSS VSS.n7 0.608227
R11 VSS.n6 VSS.n5 0.4805
R12 VSS.n7 VSS.n6 0.22325
R13 VSS.n5 VSS.n4 0.221
R14 VSS.n4 VSS 0.08
R15 VSS.n2 VSS.n0 0.0400455
R16 VSS.n7 VSS.n2 0.0395909
R17 Y.n2 Y.n1 6.3005
R18 Y.n2 Y.n0 3.15748
R19 Y.n1 Y.t2 1.6385
R20 Y.n1 Y.t1 1.6385
R21 Y.n0 Y.t0 1.31934
R22 Y.n0 Y.t3 1.31934
R23 Y Y.n2 0.0582358
R24 VDD.n2 VDD.t6 13.4599
R25 VDD.n2 VDD.t5 13.4002
R26 VDD.n4 VDD.n0 5.28659
R27 VDD.n3 VDD.n1 5.28659
R28 VDD.n5 VDD.t2 4.24775
R29 VDD.n0 VDD.t4 1.31934
R30 VDD.n0 VDD.t0 1.31934
R31 VDD.n1 VDD.t1 1.31934
R32 VDD.n1 VDD.t3 1.31934
R33 VDD.n3 VDD.n2 0.4565
R34 VDD.n5 VDD.n4 0.3395
R35 VDD.n4 VDD.n3 0.2405
R36 VDD VDD.n5 0.0815
R37 C.n0 C.t3 29.7219
R38 C.n2 C.t2 26.9258
R39 C.n0 C.t1 23.7255
R40 C.n1 C.t0 21.3803
R41 C.n1 C.n0 16.5048
R42 C C.n2 8.02466
R43 C.n2 C.n1 0.134445
R44 B.n0 B.t2 24.5076
R45 B.n1 B.t3 24.5076
R46 B.n0 B.t0 19.5541
R47 B.n1 B.t1 19.5541
R48 B.n2 B.n0 8.11161
R49 B.n2 B.n1 8.11161
R50 B B.n2 4.1355
R51 A.n0 A.t1 27.3301
R52 A.n0 A.t0 22.6372
R53 A A.n0 8.06606
R54 VNW.t3 VNW.t4 558.14
R55 VNW.t8 VNW.t0 558.14
R56 VNW VNW.t8 352.714
R57 VNW.t4 VNW.t5 310.079
R58 VNW.t2 VNW.t3 310.079
R59 VNW.t1 VNW.t2 310.079
R60 VNW.t7 VNW.t1 310.079
R61 VNW.t6 VNW.t7 310.079
R62 VNW.t0 VNW.t6 310.079
R63 VPW.t3 VPW.t4 2127.27
R64 VPW.t8 VPW.t0 2127.27
R65 VPW VPW.t8 1344.32
R66 VPW.t4 VPW.t5 1181.82
R67 VPW.t2 VPW.t3 1181.82
R68 VPW.t1 VPW.t2 1181.82
R69 VPW.t7 VPW.t1 1181.82
R70 VPW.t6 VPW.t7 1181.82
R71 VPW.t0 VPW.t6 1181.82
C0 a_364_440# C 0.06161f
C1 B VNW 0.1553f
C2 a_220_68# C 0.03655f
C3 a_668_68# C 0.29278f
C4 VNW C 0.18307f
C5 a_364_440# a_220_68# 0.68189f
C6 a_364_440# a_668_68# 0.08258f
C7 Y VDD 0.11021f
C8 VSS VDD 0.03845f
C9 a_364_440# VNW 0.02672f
C10 a_220_68# a_668_68# 0.14609f
C11 B Y 0
C12 B VSS 0.04008f
C13 a_220_68# a_828_68# 0
C14 a_668_68# a_828_68# 0.01051f
C15 a_220_68# a_508_68# 0.00687f
C16 VNW a_220_68# 0.22177f
C17 a_668_68# a_508_68# 0.00197f
C18 a_220_68# A 0.21338f
C19 VNW a_668_68# 0.20537f
C20 VNW A 0.09871f
C21 Y C 0.01383f
C22 VSS C 0.03492f
C23 a_364_440# Y 0.01715f
C24 a_364_440# VSS 0
C25 B VDD 0.03132f
C26 Y a_220_68# 0
C27 Y a_668_68# 0.20522f
C28 a_220_68# VSS 0.11813f
C29 VSS a_668_68# 0.45152f
C30 Y a_828_68# 0
C31 VSS a_828_68# 0.00928f
C32 Y a_508_68# 0
C33 Y VNW 0.02244f
C34 VSS a_508_68# 0.01142f
C35 VNW VSS 0.01162f
C36 VSS A 0.0388f
C37 C VDD 0.0211f
C38 a_364_440# VDD 0.79552f
C39 B a_364_440# 0.02378f
C40 a_220_68# VDD 0.19433f
C41 a_668_68# VDD 0.07535f
C42 Y VSS 0.03318f
C43 VNW VDD 0.27235f
C44 B a_220_68# 0.30645f
C45 A VDD 0.05083f
C46 B a_668_68# 0.12743f
C47 VSS VPW 0.19076f
C48 Y VPW 0.06262f
C49 VDD VPW 0.47482f
C50 C VPW 0.302f
C51 B VPW 0.30735f
C52 A VPW 0.25655f
C53 VNW VPW 3.3215f
C54 a_364_440# VPW 0.00297f
C55 a_668_68# VPW 0.26245f
C56 a_220_68# VPW 0.22804f
C57 VNW.t5 VPW 0.19725f
C58 VNW.t4 VPW 0.12919f
C59 VNW.t3 VPW 0.12919f
C60 VNW.t2 VPW 0.09228f
C61 VNW.t1 VPW 0.09228f
C62 VNW.t7 VPW 0.09228f
C63 VNW.t6 VPW 0.09228f
C64 VNW.t0 VPW 0.12919f
C65 VNW.t8 VPW 0.13554f
C66 A.t1 VPW 0.09652f
C67 A.t0 VPW 0.06977f
C68 A.n0 VPW 0.12418f
C69 B.t2 VPW 0.08403f
C70 B.t0 VPW 0.05855f
C71 B.n0 VPW 0.11462f
C72 B.t3 VPW 0.08403f
C73 B.t1 VPW 0.05855f
C74 B.n1 VPW 0.11462f
C75 B.n2 VPW 0.04901f
C76 C.t2 VPW 0.08661f
C77 C.t3 VPW 0.09002f
C78 C.t1 VPW 0.06362f
C79 C.n0 VPW 0.10721f
C80 C.t0 VPW 0.06106f
C81 C.n1 VPW 0.07642f
C82 C.n2 VPW 0.06931f
C83 VDD.t2 VPW 0.08211f
C84 VDD.t4 VPW 0.02963f
C85 VDD.t0 VPW 0.02963f
C86 VDD.n0 VPW 0.05944f
C87 VDD.t1 VPW 0.02963f
C88 VDD.t3 VPW 0.02963f
C89 VDD.n1 VPW 0.05944f
C90 VDD.t5 VPW 0.08122f
C91 VDD.t6 VPW 0.08611f
C92 VDD.n2 VPW 0.42193f
C93 VDD.n3 VPW 0.24456f
C94 VDD.n4 VPW 0.20591f
C95 VDD.n5 VPW 0.20346f
C96 Y.t0 VPW 0.0386f
C97 Y.t3 VPW 0.0386f
C98 Y.n0 VPW 0.09138f
C99 Y.t2 VPW 0.02797f
C100 Y.t1 VPW 0.02797f
C101 Y.n1 VPW 0.05594f
C102 Y.n2 VPW 0.11781f
C103 VSS.t5 VPW 0.0338f
C104 VSS.n0 VPW 0.3166f
C105 VSS.t6 VPW 0.02439f
C106 VSS.t1 VPW 0.02397f
C107 VSS.n1 VPW 0.04836f
C108 VSS.n2 VPW 0.0357f
C109 VSS.t4 VPW 0.01084f
C110 VSS.t2 VPW 0.01084f
C111 VSS.n3 VPW 0.02175f
C112 VSS.t3 VPW 0.03152f
C113 VSS.t0 VPW 0.03388f
C114 VSS.n4 VPW 0.06282f
C115 VSS.n5 VPW 0.12948f
C116 VSS.n6 VPW 0.12461f
C117 VSS.n7 VPW 0.33084f
.ends

* NGSPICE file created from gf180mcu_as_sc_mcu7t3v3__ao21b_4.ext - technology: gf180mcuD

.subckt gf180mcu_as_sc_mcu7t3v3__ao21b_4 VDD VNW VPW VSS Y C B A
X0 a_364_440# C.t2 a_668_68# VNW.t5 pfet_03v3 ad=0.6072p pd=3.64u as=0.3588p ps=1.9u w=1.38u l=0.28u
X1 Y.t6 a_668_68# VDD.t3 VNW.t0 pfet_03v3 ad=0.3588p pd=1.9u as=0.6072p ps=3.64u w=1.38u l=0.28u
X2 VSS.t3 a_668_68# Y.t1 VPW.t1 nfet_03v3 ad=0.26p pd=1.52u as=0.26p ps=1.52u w=1u l=0.28u
X3 a_668_68# B.t1 a_508_68# VPW.t8 nfet_03v3 ad=0.26p pd=1.52u as=0.26p ps=1.52u w=1u l=0.28u
X4 VSS.t2 C.t0 a_668_68# VPW.t5 nfet_03v3 ad=0.58p pd=2.16u as=0.26p ps=1.52u w=1u l=0.28u
X5 a_220_68# A.t0 VSS.t1 VPW.t10 nfet_03v3 ad=0.44p pd=2.88u as=0.47p ps=2.94u w=1u l=0.28u
X6 Y.t0 a_668_68# VSS.t6 VPW.t0 nfet_03v3 ad=0.26p pd=1.52u as=0.58p ps=2.16u w=1u l=0.28u
X7 a_508_68# a_220_68# VSS.t8 VPW.t6 nfet_03v3 ad=0.26p pd=1.52u as=0.44p ps=2.88u w=1u l=0.28u
X8 a_220_68# A.t1 VDD.t1 VNW.t10 pfet_03v3 ad=0.6072p pd=3.64u as=0.6348p ps=3.68u w=1.38u l=0.28u
X9 VDD.t7 a_220_68# a_364_440# VNW.t6 pfet_03v3 ad=0.3588p pd=1.9u as=0.6072p ps=3.64u w=1.38u l=0.28u
X10 a_364_440# a_220_68# VDD.t8 VNW.t7 pfet_03v3 ad=0.3588p pd=1.9u as=0.3588p ps=1.9u w=1.38u l=0.28u
X11 a_668_68# C.t1 VSS.t0 VPW.t4 nfet_03v3 ad=0.26p pd=1.52u as=0.26p ps=1.52u w=1u l=0.28u
X12 VDD.t4 a_668_68# Y.t7 VNW.t1 pfet_03v3 ad=0.3588p pd=1.9u as=0.3588p ps=1.9u w=1.38u l=0.28u
X13 a_668_68# C.t3 a_364_440# VNW.t4 pfet_03v3 ad=0.3588p pd=1.9u as=0.3588p ps=1.9u w=1.38u l=0.28u
X14 Y.t5 a_668_68# VDD.t5 VNW.t2 pfet_03v3 ad=0.3588p pd=1.9u as=0.3588p ps=1.9u w=1.38u l=0.28u
X15 VSS.t7 a_220_68# a_828_68# VPW.t7 nfet_03v3 ad=0.26p pd=1.52u as=0.26p ps=1.52u w=1u l=0.28u
X16 a_364_440# B.t3 VDD.t2 VNW.t8 pfet_03v3 ad=0.3588p pd=1.9u as=0.3588p ps=1.9u w=1.38u l=0.28u
X17 VDD.t6 a_668_68# Y.t4 VNW.t3 pfet_03v3 ad=0.7314p pd=3.82u as=0.3588p ps=1.9u w=1.38u l=0.28u
X18 Y.t2 a_668_68# VSS.t4 VPW.t2 nfet_03v3 ad=0.26p pd=1.52u as=0.26p ps=1.52u w=1u l=0.28u
X19 a_828_68# B.t0 a_668_68# VPW.t9 nfet_03v3 ad=0.26p pd=1.52u as=0.26p ps=1.52u w=1u l=0.28u
X20 VSS.t5 a_668_68# Y.t3 VPW.t3 nfet_03v3 ad=0.53p pd=3.06u as=0.26p ps=1.52u w=1u l=0.28u
X21 VDD.t0 B.t2 a_364_440# VNW.t9 pfet_03v3 ad=0.3588p pd=1.9u as=0.3588p ps=1.9u w=1.38u l=0.28u
R0 VSS.n7 VSS.t8 10.9684
R1 VSS.n6 VSS.t1 10.6759
R2 VSS.n1 VSS.t5 10.4304
R3 VSS.n1 VSS.n0 6.38659
R4 VSS.n8 VSS.n5 6.38659
R5 VSS.n3 VSS.t6 3.686
R6 VSS.n3 VSS.t2 3.623
R7 VSS.n4 VSS.n3 3.1505
R8 VSS.n0 VSS.t4 1.6385
R9 VSS.n0 VSS.t3 1.6385
R10 VSS.n5 VSS.t0 1.6385
R11 VSS.n5 VSS.t7 1.6385
R12 VSS.n2 VSS 1.133
R13 VSS VSS.n9 0.608227
R14 VSS.n8 VSS.n7 0.4805
R15 VSS.n2 VSS.n1 0.224
R16 VSS.n9 VSS.n8 0.22325
R17 VSS.n7 VSS.n6 0.221
R18 VSS.n6 VSS 0.08
R19 VSS.n4 VSS.n2 0.0400455
R20 VSS.n9 VSS.n4 0.0395909
R21 Y.n7 Y.n6 6.3005
R22 Y.n3 Y.n2 6.3005
R23 Y.n5 Y.n0 2.95031
R24 Y.n4 Y.n1 2.95031
R25 Y.n2 Y.t3 1.6385
R26 Y.n2 Y.t2 1.6385
R27 Y.n6 Y.t1 1.6385
R28 Y.n6 Y.t0 1.6385
R29 Y.n1 Y.t4 1.31934
R30 Y.n1 Y.t5 1.31934
R31 Y.n0 Y.t7 1.31934
R32 Y.n0 Y.t6 1.31934
R33 Y.n5 Y.n4 0.4775
R34 Y.n7 Y.n5 0.20767
R35 Y.n4 Y.n3 0.20767
R36 Y Y.n7 0.0582358
R37 Y.n3 Y 0.0582358
R38 VDD.n4 VDD.t3 13.4002
R39 VDD.n3 VDD.t6 12.2624
R40 VDD.n6 VDD.n0 5.28659
R41 VDD.n5 VDD.n1 5.28659
R42 VDD.n3 VDD.n2 5.28659
R43 VDD.n7 VDD.t1 4.24775
R44 VDD.n0 VDD.t2 1.31934
R45 VDD.n0 VDD.t7 1.31934
R46 VDD.n1 VDD.t8 1.31934
R47 VDD.n1 VDD.t0 1.31934
R48 VDD.n2 VDD.t5 1.31934
R49 VDD.n2 VDD.t4 1.31934
R50 VDD.n5 VDD.n4 0.4565
R51 VDD.n7 VDD.n6 0.3395
R52 VDD.n4 VDD.n3 0.2405
R53 VDD.n6 VDD.n5 0.2405
R54 VDD VDD.n7 0.0815
R55 C.n0 C.t3 29.7219
R56 C.n2 C.t2 26.9258
R57 C.n0 C.t1 23.7255
R58 C.n1 C.t0 21.3803
R59 C.n1 C.n0 16.5048
R60 C C.n2 8.02466
R61 C.n2 C.n1 0.134445
R62 B.n0 B.t2 24.5076
R63 B.n1 B.t3 24.5076
R64 B.n0 B.t0 19.5541
R65 B.n1 B.t1 19.5541
R66 B.n2 B.n0 8.11161
R67 B.n2 B.n1 8.11161
R68 B B.n2 4.1355
R69 A.n0 A.t1 27.3301
R70 A.n0 A.t0 22.6372
R71 A A.n0 8.06606
R72 VNW.t5 VNW.t0 558.14
R73 VNW.t10 VNW.t6 558.14
R74 VNW VNW.t10 352.714
R75 VNW.t2 VNW.t3 310.079
R76 VNW.t1 VNW.t2 310.079
R77 VNW.t0 VNW.t1 310.079
R78 VNW.t4 VNW.t5 310.079
R79 VNW.t7 VNW.t4 310.079
R80 VNW.t9 VNW.t7 310.079
R81 VNW.t8 VNW.t9 310.079
R82 VNW.t6 VNW.t8 310.079
R83 VPW.t5 VPW.t0 2127.27
R84 VPW.t10 VPW.t6 2127.27
R85 VPW VPW.t10 1344.32
R86 VPW.t2 VPW.t3 1181.82
R87 VPW.t1 VPW.t2 1181.82
R88 VPW.t0 VPW.t1 1181.82
R89 VPW.t4 VPW.t5 1181.82
R90 VPW.t7 VPW.t4 1181.82
R91 VPW.t9 VPW.t7 1181.82
R92 VPW.t8 VPW.t9 1181.82
R93 VPW.t6 VPW.t8 1181.82
C0 a_364_440# VNW 0.02672f
C1 a_220_68# C 0.03655f
C2 A VDD 0.05083f
C3 a_364_440# a_668_68# 0.08258f
C4 B VNW 0.1553f
C5 VSS VNW 0.01191f
C6 Y VNW 0.0346f
C7 a_668_68# B 0.12743f
C8 a_668_68# VSS 0.49118f
C9 a_668_68# Y 0.31838f
C10 a_220_68# A 0.21338f
C11 VSS a_508_68# 0.01142f
C12 Y a_508_68# 0
C13 a_364_440# C 0.06161f
C14 a_220_68# VDD 0.19433f
C15 a_668_68# VNW 0.38108f
C16 a_220_68# a_828_68# 0
C17 VSS C 0.03492f
C18 Y C 0.01383f
C19 VSS A 0.0388f
C20 a_668_68# a_508_68# 0.00197f
C21 VNW C 0.18307f
C22 a_364_440# VDD 0.79552f
C23 a_668_68# C 0.29278f
C24 B VDD 0.03132f
C25 Y VDD 0.26393f
C26 VSS VDD 0.04047f
C27 VNW A 0.09871f
C28 a_364_440# a_220_68# 0.68189f
C29 VSS a_828_68# 0.00928f
C30 Y a_828_68# 0
C31 a_220_68# B 0.30645f
C32 a_220_68# VSS 0.11813f
C33 a_220_68# Y 0
C34 VNW VDD 0.31215f
C35 a_668_68# VDD 0.11468f
C36 a_220_68# VNW 0.22177f
C37 a_668_68# a_828_68# 0.01051f
C38 a_220_68# a_668_68# 0.14609f
C39 a_364_440# B 0.02378f
C40 a_364_440# VSS 0
C41 a_364_440# Y 0.01715f
C42 B Y 0
C43 B VSS 0.04008f
C44 Y VSS 0.11804f
C45 C VDD 0.0211f
C46 a_220_68# a_508_68# 0.00687f
C47 VSS VPW 0.29456f
C48 Y VPW 0.07584f
C49 VDD VPW 0.53655f
C50 C VPW 0.302f
C51 B VPW 0.30735f
C52 A VPW 0.25655f
C53 VNW VPW 3.84428f
C54 a_364_440# VPW 0.00297f
C55 a_668_68# VPW 0.47446f
C56 a_220_68# VPW 0.22804f
C57 VNW.t3 VPW 0.21155f
C58 VNW.t2 VPW 0.09455f
C59 VNW.t1 VPW 0.09455f
C60 VNW.t0 VPW 0.13237f
C61 VNW.t5 VPW 0.13237f
C62 VNW.t4 VPW 0.09455f
C63 VNW.t7 VPW 0.09455f
C64 VNW.t9 VPW 0.09455f
C65 VNW.t8 VPW 0.09455f
C66 VNW.t6 VPW 0.13237f
C67 VNW.t10 VPW 0.13887f
C68 A.t1 VPW 0.09652f
C69 A.t0 VPW 0.06977f
C70 A.n0 VPW 0.12418f
C71 B.t2 VPW 0.08403f
C72 B.t0 VPW 0.05855f
C73 B.n0 VPW 0.11462f
C74 B.t3 VPW 0.08403f
C75 B.t1 VPW 0.05855f
C76 B.n1 VPW 0.11462f
C77 B.n2 VPW 0.04901f
C78 C.t2 VPW 0.08661f
C79 C.t3 VPW 0.09002f
C80 C.t1 VPW 0.06362f
C81 C.n0 VPW 0.10721f
C82 C.t0 VPW 0.06106f
C83 C.n1 VPW 0.07642f
C84 C.n2 VPW 0.06931f
C85 VDD.t1 VPW 0.07853f
C86 VDD.t2 VPW 0.02834f
C87 VDD.t7 VPW 0.02834f
C88 VDD.n0 VPW 0.05684f
C89 VDD.t8 VPW 0.02834f
C90 VDD.t0 VPW 0.02834f
C91 VDD.n1 VPW 0.05684f
C92 VDD.t3 VPW 0.07767f
C93 VDD.t5 VPW 0.02834f
C94 VDD.t4 VPW 0.02834f
C95 VDD.n2 VPW 0.05684f
C96 VDD.t6 VPW 0.0984f
C97 VDD.n3 VPW 0.32585f
C98 VDD.n4 VPW 0.2523f
C99 VDD.n5 VPW 0.23389f
C100 VDD.n6 VPW 0.19693f
C101 VDD.n7 VPW 0.19458f
C102 Y.t7 VPW 0.03374f
C103 Y.t6 VPW 0.03374f
C104 Y.n0 VPW 0.07401f
C105 Y.t4 VPW 0.03374f
C106 Y.t5 VPW 0.03374f
C107 Y.n1 VPW 0.07401f
C108 Y.t3 VPW 0.02445f
C109 Y.t2 VPW 0.02445f
C110 Y.n2 VPW 0.0489f
C111 Y.n3 VPW 0.01944f
C112 Y.n4 VPW 0.12055f
C113 Y.n5 VPW 0.12055f
C114 Y.t1 VPW 0.02445f
C115 Y.t0 VPW 0.02445f
C116 Y.n6 VPW 0.0489f
C117 Y.n7 VPW 0.01944f
C118 VSS.t4 VPW 0.01067f
C119 VSS.t3 VPW 0.01067f
C120 VSS.n0 VPW 0.02141f
C121 VSS.t5 VPW 0.03986f
C122 VSS.n1 VPW 0.16133f
C123 VSS.n2 VPW 0.24023f
C124 VSS.t6 VPW 0.024f
C125 VSS.t2 VPW 0.02359f
C126 VSS.n3 VPW 0.0476f
C127 VSS.n4 VPW 0.03514f
C128 VSS.t0 VPW 0.01067f
C129 VSS.t7 VPW 0.01067f
C130 VSS.n5 VPW 0.02141f
C131 VSS.t8 VPW 0.03102f
C132 VSS.t1 VPW 0.03334f
C133 VSS.n6 VPW 0.06183f
C134 VSS.n7 VPW 0.12742f
C135 VSS.n8 VPW 0.12263f
C136 VSS.n9 VPW 0.32559f
.ends

* NGSPICE file created from gf180mcu_as_sc_mcu7t3v3__ao22_2.ext - technology: gf180mcuD

.subckt gf180mcu_as_sc_mcu7t3v3__ao22_2 VDD VNW VPW VSS A B C D Y
X0 a_620_68# C.t0 a_28_440# VPW.t3 nfet_03v3 ad=0.26p pd=1.52u as=0.44p ps=2.88u w=1u l=0.28u
X1 a_28_440# B.t1 a_172_440# VNW.t4 pfet_03v3 ad=0.6072p pd=3.64u as=0.3588p ps=1.9u w=1.38u l=0.28u
X2 a_172_440# C.t1 VDD.t1 VNW.t3 pfet_03v3 ad=0.3588p pd=1.9u as=0.6072p ps=3.64u w=1.38u l=0.28u
X3 a_172_68# A.t0 VSS.t1 VPW.t5 nfet_03v3 ad=0.26p pd=1.52u as=0.44p ps=2.88u w=1u l=0.28u
X4 VDD.t3 a_28_440# Y.t3 VNW.t2 pfet_03v3 ad=0.7176p pd=3.8u as=0.3588p ps=1.9u w=1.38u l=0.28u
X5 VSS.t3 a_28_440# Y.t1 VPW.t2 nfet_03v3 ad=0.52p pd=3.04u as=0.26p ps=1.52u w=1u l=0.28u
X6 VDD.t0 D.t1 a_172_440# VNW.t0 pfet_03v3 ad=0.3588p pd=1.9u as=0.3588p ps=1.9u w=1.38u l=0.28u
X7 Y.t2 a_28_440# VDD.t2 VNW.t1 pfet_03v3 ad=0.3588p pd=1.9u as=0.3588p ps=1.9u w=1.38u l=0.28u
X8 Y.t0 a_28_440# VSS.t2 VPW.t1 nfet_03v3 ad=0.26p pd=1.52u as=0.26p ps=1.52u w=1u l=0.28u
X9 VSS.t0 D.t0 a_620_68# VPW.t0 nfet_03v3 ad=0.26p pd=1.52u as=0.26p ps=1.52u w=1u l=0.28u
X10 a_172_440# A.t1 a_28_440# VNW.t5 pfet_03v3 ad=0.3588p pd=1.9u as=0.6072p ps=3.64u w=1.38u l=0.28u
X11 a_28_440# B.t0 a_172_68# VPW.t4 nfet_03v3 ad=0.44p pd=2.88u as=0.26p ps=1.52u w=1u l=0.28u
R0 VSS.n2 VSS.t1 10.9684
R1 VSS.n1 VSS.n0 6.38659
R2 VSS.n1 VSS.t3 5.2398
R3 VSS.n0 VSS.t2 1.6385
R4 VSS.n0 VSS.t0 1.6385
R5 VSS.n2 VSS.n1 0.5765
R6 VSS VSS.n2 0.0485
R7 Y.n2 Y.n1 6.3005
R8 Y.n2 Y.n0 3.0411
R9 Y.n1 Y.t1 1.6385
R10 Y.n1 Y.t0 1.6385
R11 Y.n0 Y.t3 1.31934
R12 Y.n0 Y.t2 1.31934
R13 Y Y.n2 0.0488582
R14 VDD.n2 VDD.t1 13.4002
R15 VDD.n1 VDD.n0 5.28659
R16 VDD.n1 VDD.t3 3.57833
R17 VDD.n0 VDD.t2 1.31934
R18 VDD.n0 VDD.t0 1.31934
R19 VDD VDD.n2 0.3845
R20 VDD.n2 VDD.n1 0.2405
R21 D.n0 D.t1 26.211
R22 D.n0 D.t0 21.7615
R23 D D.n0 8.0535
R24 C.n0 C.t1 25.7194
R25 C.n0 C.t0 20.6226
R26 C C.n0 8.0375
R27 B.n0 B.t1 26.35
R28 B.n0 B.t0 21.6224
R29 B B.n0 8.0525
R30 A.n0 A.t1 26.7058
R31 A.n0 A.t0 22.2737
R32 A A.n0 8.0545
R33 VNW.t4 VNW.t3 558.14
R34 VNW.t1 VNW.t2 310.079
R35 VNW.t0 VNW.t1 310.079
R36 VNW.t3 VNW.t0 310.079
R37 VNW.t5 VNW.t4 310.079
R38 VNW VNW.t5 259.69
R39 VPW.t4 VPW.t3 2127.27
R40 VPW.t1 VPW.t2 1181.82
R41 VPW.t0 VPW.t1 1181.82
R42 VPW.t3 VPW.t0 1181.82
R43 VPW.t5 VPW.t4 1181.82
R44 VPW VPW.t5 989.774
C0 Y VDD 0.2273f
C1 D VNW 0.08145f
C2 VSS A 0.03974f
C3 a_172_440# VSS 0
C4 a_620_68# VSS 0.00512f
C5 C VNW 0.10321f
C6 VDD VNW 0.17482f
C7 Y A 0
C8 Y a_172_440# 0.01728f
C9 Y a_620_68# 0
C10 B a_28_440# 0.14914f
C11 VNW A 0.08894f
C12 a_172_440# VNW 0.01483f
C13 D a_28_440# 0.33523f
C14 C B 0.05072f
C15 Y VSS 0.07721f
C16 C a_28_440# 0.18212f
C17 VDD B 0.01009f
C18 VDD a_28_440# 0.56578f
C19 C D 0.07098f
C20 VSS VNW 0.00733f
C21 a_172_68# B 0.00161f
C22 D VDD 0.01825f
C23 a_172_68# a_28_440# 0.00758f
C24 C VDD 0.01775f
C25 A B 0.08549f
C26 a_172_440# B 0.00813f
C27 A a_28_440# 0.14756f
C28 a_172_440# a_28_440# 0.91f
C29 Y VNW 0.02733f
C30 a_620_68# a_28_440# 0.016f
C31 a_172_440# D 0.00369f
C32 D a_620_68# 0
C33 C a_172_440# 0.01288f
C34 VDD A 0.00875f
C35 VSS B 0.02838f
C36 a_172_440# VDD 0.14488f
C37 VSS a_28_440# 0.60798f
C38 D VSS 0.01572f
C39 C VSS 0.01063f
C40 VDD VSS 0.03149f
C41 Y B 0
C42 Y a_28_440# 0.34329f
C43 a_172_440# A 0.00215f
C44 a_172_68# VSS 0.01078f
C45 VNW B 0.08971f
C46 Y D 0.00304f
C47 VNW a_28_440# 0.22325f
C48 Y C 0
C49 VSS VPW 0.47828f
C50 Y VPW 0.03631f
C51 VDD VPW 0.4689f
C52 D VPW 0.20599f
C53 C VPW 0.20671f
C54 B VPW 0.19252f
C55 A VPW 0.21446f
C56 VNW VPW 2.26753f
C57 a_172_440# VPW 0
C58 a_28_440# VPW 0.29708f
C59 VNW.t2 VPW 0.18828f
C60 VNW.t1 VPW 0.09241f
C61 VNW.t0 VPW 0.09241f
C62 VNW.t3 VPW 0.12937f
C63 VNW.t4 VPW 0.12937f
C64 VNW.t5 VPW 0.0849f
C65 A.t1 VPW 0.0937f
C66 A.t0 VPW 0.06802f
C67 A.n0 VPW 0.13191f
C68 B.t1 VPW 0.10452f
C69 B.t0 VPW 0.07476f
C70 B.n0 VPW 0.15609f
C71 C.t1 VPW 0.10297f
C72 C.t0 VPW 0.07173f
C73 C.n0 VPW 0.18711f
C74 D.t1 VPW 0.12991f
C75 D.t0 VPW 0.09389f
C76 D.n0 VPW 0.19484f
C77 VDD.t1 VPW 0.09427f
C78 VDD.t2 VPW 0.03439f
C79 VDD.t0 VPW 0.03439f
C80 VDD.n0 VPW 0.06899f
C81 VDD.t3 VPW 0.117f
C82 VDD.n1 VPW 0.42424f
C83 VDD.n2 VPW 0.27859f
C84 Y.t3 VPW 0.06109f
C85 Y.t2 VPW 0.06109f
C86 Y.n0 VPW 0.14548f
C87 Y.t1 VPW 0.04426f
C88 Y.t0 VPW 0.04426f
C89 Y.n1 VPW 0.08853f
C90 Y.n2 VPW 0.24133f
C91 VSS.t1 VPW 0.05628f
C92 VSS.t2 VPW 0.01935f
C93 VSS.t0 VPW 0.01935f
C94 VSS.n0 VPW 0.03884f
C95 VSS.t3 VPW 0.067f
C96 VSS.n1 VPW 0.41097f
C97 VSS.n2 VPW 0.20839f
.ends

* NGSPICE file created from gf180mcu_as_sc_mcu7t3v3__ao22_4.ext - technology: gf180mcuD

.subckt gf180mcu_as_sc_mcu7t3v3__ao22_4 VDD VNW VPW VSS A B C D Y
X0 a_620_68# C.t0 a_28_440# VPW.t5 nfet_03v3 ad=0.26p pd=1.52u as=0.44p ps=2.88u w=1u l=0.28u
X1 a_28_440# B.t1 a_172_440# VNW.t6 pfet_03v3 ad=0.6072p pd=3.64u as=0.3588p ps=1.9u w=1.38u l=0.28u
X2 a_172_440# C.t1 VDD.t0 VNW.t5 pfet_03v3 ad=0.3588p pd=1.9u as=0.6072p ps=3.64u w=1.38u l=0.28u
X3 Y.t4 a_28_440# VSS.t2 VPW.t3 nfet_03v3 ad=0.26p pd=1.52u as=0.26p ps=1.52u w=1u l=0.28u
X4 a_172_68# A.t0 VSS.t0 VPW.t7 nfet_03v3 ad=0.26p pd=1.52u as=0.44p ps=2.88u w=1u l=0.28u
X5 VDD.t2 a_28_440# Y.t0 VNW.t2 pfet_03v3 ad=0.3588p pd=1.9u as=0.3588p ps=1.9u w=1.38u l=0.28u
X6 VSS.t3 a_28_440# Y.t3 VPW.t2 nfet_03v3 ad=0.26p pd=1.52u as=0.26p ps=1.52u w=1u l=0.28u
X7 VDD.t5 D.t1 a_172_440# VNW.t0 pfet_03v3 ad=0.3588p pd=1.9u as=0.3588p ps=1.9u w=1.38u l=0.28u
X8 Y.t1 a_28_440# VDD.t3 VNW.t3 pfet_03v3 ad=0.3588p pd=1.9u as=0.3588p ps=1.9u w=1.38u l=0.28u
X9 Y.t7 a_28_440# VDD.t1 VNW.t1 pfet_03v3 ad=0.3588p pd=1.9u as=0.3588p ps=1.9u w=1.38u l=0.28u
X10 Y.t2 a_28_440# VSS.t4 VPW.t1 nfet_03v3 ad=0.26p pd=1.52u as=0.26p ps=1.52u w=1u l=0.28u
X11 VDD.t4 a_28_440# Y.t6 VNW.t4 pfet_03v3 ad=0.6072p pd=3.64u as=0.3588p ps=1.9u w=1.38u l=0.28u
X12 VSS.t1 D.t0 a_620_68# VPW.t0 nfet_03v3 ad=0.26p pd=1.52u as=0.26p ps=1.52u w=1u l=0.28u
X13 a_172_440# A.t1 a_28_440# VNW.t7 pfet_03v3 ad=0.3588p pd=1.9u as=0.6072p ps=3.64u w=1.38u l=0.28u
X14 VSS.t5 a_28_440# Y.t5 VPW.t4 nfet_03v3 ad=0.44p pd=2.88u as=0.26p ps=1.52u w=1u l=0.28u
X15 a_28_440# B.t0 a_172_68# VPW.t6 nfet_03v3 ad=0.44p pd=2.88u as=0.26p ps=1.52u w=1u l=0.28u
R0 VSS.n4 VSS.t0 10.9684
R1 VSS.n3 VSS.n0 6.38659
R2 VSS.n2 VSS.t5 5.2398
R3 VSS.n2 VSS.n1 3.3618
R4 VSS.n1 VSS.t2 1.6385
R5 VSS.n1 VSS.t3 1.6385
R6 VSS.n0 VSS.t4 1.6385
R7 VSS.n0 VSS.t1 1.6385
R8 VSS.n4 VSS.n3 0.5765
R9 VSS.n3 VSS.n2 0.2405
R10 VSS VSS.n4 0.0485
R11 Y.n2 Y.n1 6.46438
R12 Y.n6 Y.n5 6.3005
R13 Y.n2 Y.n0 2.87856
R14 Y.n4 Y.n3 2.87856
R15 Y.n5 Y.t3 1.6385
R16 Y.n5 Y.t2 1.6385
R17 Y.n1 Y.t5 1.6385
R18 Y.n1 Y.t4 1.6385
R19 Y.n3 Y.t0 1.31934
R20 Y.n3 Y.t7 1.31934
R21 Y.n0 Y.t6 1.31934
R22 Y.n0 Y.t1 1.31934
R23 Y.n4 Y.n2 0.4955
R24 Y.n6 Y.n4 0.163037
R25 Y Y.n6 0.0488582
R26 VDD.n4 VDD.t0 13.4002
R27 VDD.n3 VDD.n0 5.28659
R28 VDD.n2 VDD.t4 3.57833
R29 VDD.n2 VDD.n1 2.01949
R30 VDD.n0 VDD.t1 1.31934
R31 VDD.n0 VDD.t5 1.31934
R32 VDD.n1 VDD.t3 1.31934
R33 VDD.n1 VDD.t2 1.31934
R34 VDD VDD.n4 0.3845
R35 VDD.n3 VDD.n2 0.2405
R36 VDD.n4 VDD.n3 0.2405
R37 D.n0 D.t1 26.211
R38 D.n0 D.t0 21.7615
R39 D D.n0 8.0535
R40 C.n0 C.t1 25.7194
R41 C.n0 C.t0 20.6226
R42 C C.n0 8.0375
R43 B.n0 B.t1 26.35
R44 B.n0 B.t0 21.6224
R45 B B.n0 8.0525
R46 A.n0 A.t1 26.7058
R47 A.n0 A.t0 22.2737
R48 A A.n0 8.0545
R49 VNW.t6 VNW.t5 558.14
R50 VNW.t3 VNW.t4 310.079
R51 VNW.t2 VNW.t3 310.079
R52 VNW.t1 VNW.t2 310.079
R53 VNW.t0 VNW.t1 310.079
R54 VNW.t5 VNW.t0 310.079
R55 VNW.t7 VNW.t6 310.079
R56 VNW VNW.t7 259.69
R57 VPW.t6 VPW.t5 2127.27
R58 VPW.t3 VPW.t4 1181.82
R59 VPW.t2 VPW.t3 1181.82
R60 VPW.t1 VPW.t2 1181.82
R61 VPW.t0 VPW.t1 1181.82
R62 VPW.t5 VPW.t0 1181.82
R63 VPW.t7 VPW.t6 1181.82
R64 VPW VPW.t7 989.774
C0 A a_172_440# 0.00215f
C1 VSS a_620_68# 0.00512f
C2 D a_28_440# 0.33523f
C3 Y a_172_440# 0.01728f
C4 VDD a_28_440# 0.62403f
C5 VSS a_28_440# 0.66206f
C6 D a_172_440# 0.00369f
C7 B a_28_440# 0.14914f
C8 VDD a_172_440# 0.14488f
C9 Y A 0
C10 VSS a_172_440# 0
C11 a_172_440# B 0.00813f
C12 VDD A 0.00875f
C13 C a_28_440# 0.18212f
C14 Y D 0.00304f
C15 Y VDD 0.60683f
C16 VSS A 0.03974f
C17 VNW a_28_440# 0.39901f
C18 Y VSS 0.26771f
C19 A B 0.08549f
C20 C a_172_440# 0.01288f
C21 D VDD 0.01825f
C22 Y B 0
C23 a_172_68# a_28_440# 0.00758f
C24 a_172_440# VNW 0.01483f
C25 D VSS 0.01572f
C26 VDD VSS 0.03158f
C27 VDD B 0.01009f
C28 Y C 0
C29 VSS B 0.02838f
C30 A VNW 0.08894f
C31 Y VNW 0.04809f
C32 C D 0.07098f
C33 C VDD 0.01775f
C34 a_620_68# a_28_440# 0.016f
C35 C VSS 0.01063f
C36 D VNW 0.08145f
C37 VDD VNW 0.23436f
C38 C B 0.05072f
C39 VSS VNW 0.00861f
C40 VNW B 0.08971f
C41 a_172_440# a_28_440# 0.91f
C42 VSS a_172_68# 0.01078f
C43 B a_172_68# 0.00161f
C44 Y a_620_68# 0
C45 C VNW 0.10321f
C46 A a_28_440# 0.14756f
C47 Y a_28_440# 0.4458f
C48 D a_620_68# 0
C49 VSS VPW 0.57917f
C50 Y VPW 0.04682f
C51 VDD VPW 0.54289f
C52 D VPW 0.20599f
C53 C VPW 0.20671f
C54 B VPW 0.19252f
C55 A VPW 0.21446f
C56 VNW VPW 2.79359f
C57 a_172_440# VPW 0
C58 a_28_440# VPW 0.50889f
C59 VNW.t4 VPW 0.20996f
C60 VNW.t3 VPW 0.09823f
C61 VNW.t2 VPW 0.09823f
C62 VNW.t1 VPW 0.09823f
C63 VNW.t0 VPW 0.09823f
C64 VNW.t5 VPW 0.13752f
C65 VNW.t6 VPW 0.13752f
C66 VNW.t7 VPW 0.09025f
C67 A.t1 VPW 0.0937f
C68 A.t0 VPW 0.06802f
C69 A.n0 VPW 0.13191f
C70 B.t1 VPW 0.10452f
C71 B.t0 VPW 0.07476f
C72 B.n0 VPW 0.15609f
C73 C.t1 VPW 0.10297f
C74 C.t0 VPW 0.07173f
C75 C.n0 VPW 0.18711f
C76 D.t1 VPW 0.12991f
C77 D.t0 VPW 0.09389f
C78 D.n0 VPW 0.19484f
C79 VDD.t0 VPW 0.10165f
C80 VDD.t1 VPW 0.03709f
C81 VDD.t5 VPW 0.03709f
C82 VDD.n0 VPW 0.07439f
C83 VDD.t3 VPW 0.03709f
C84 VDD.t2 VPW 0.03709f
C85 VDD.n1 VPW 0.08157f
C86 VDD.t4 VPW 0.11242f
C87 VDD.n2 VPW 0.50222f
C88 VDD.n3 VPW 0.21677f
C89 VDD.n4 VPW 0.3004f
C90 Y.t6 VPW 0.05691f
C91 Y.t1 VPW 0.05691f
C92 Y.n0 VPW 0.12518f
C93 Y.t5 VPW 0.04124f
C94 Y.t4 VPW 0.04124f
C95 Y.n1 VPW 0.08377f
C96 Y.n2 VPW 0.28957f
C97 Y.t0 VPW 0.05691f
C98 Y.t7 VPW 0.05691f
C99 Y.n3 VPW 0.12518f
C100 Y.n4 VPW 0.23959f
C101 Y.t3 VPW 0.04124f
C102 Y.t2 VPW 0.04124f
C103 Y.n5 VPW 0.08247f
C104 Y.n6 VPW 0.0417f
C105 VSS.t0 VPW 0.05593f
C106 VSS.t4 VPW 0.01923f
C107 VSS.t1 VPW 0.01923f
C108 VSS.n0 VPW 0.0386f
C109 VSS.t2 VPW 0.01923f
C110 VSS.t3 VPW 0.01923f
C111 VSS.n1 VPW 0.04021f
C112 VSS.t5 VPW 0.05878f
C113 VSS.n2 VPW 0.33409f
C114 VSS.n3 VPW 0.25461f
C115 VSS.n4 VPW 0.20709f
.ends

* NGSPICE file created from gf180mcu_as_sc_mcu7t3v3__ao31_2.ext - technology: gf180mcuD

.subckt gf180mcu_as_sc_mcu7t3v3__ao31_2 VDD VNW VPW VSS D A B C Y
X0 VSS.t1 a_28_440# Y.t3 VPW.t2 nfet_03v3 ad=0.44p pd=2.88u as=0.26p ps=1.52u w=1u l=0.28u
X1 VDD.t2 A.t1 a_172_440# VNW.t4 pfet_03v3 ad=0.3588p pd=1.9u as=0.3588p ps=1.9u w=1.38u l=0.28u
X2 Y.t1 a_28_440# VDD.t3 VNW.t1 pfet_03v3 ad=0.3588p pd=1.9u as=0.3588p ps=1.9u w=1.38u l=0.28u
X3 a_28_440# D.t0 VSS.t0 VPW.t5 nfet_03v3 ad=0.26p pd=1.52u as=0.44p ps=2.88u w=1u l=0.28u
X4 Y.t2 a_28_440# VSS.t2 VPW.t1 nfet_03v3 ad=0.26p pd=1.52u as=0.26p ps=1.52u w=1u l=0.28u
X5 a_172_440# B.t1 VDD.t0 VNW.t3 pfet_03v3 ad=0.3588p pd=1.9u as=0.3588p ps=1.9u w=1.38u l=0.28u
X6 VDD.t4 a_28_440# Y.t0 VNW.t2 pfet_03v3 ad=0.6072p pd=3.64u as=0.3588p ps=1.9u w=1.38u l=0.28u
X7 VSS.t3 C.t0 a_492_68# VPW.t0 nfet_03v3 ad=0.26p pd=1.52u as=0.26p ps=1.52u w=1u l=0.28u
X8 VDD.t1 C.t1 a_172_440# VNW.t0 pfet_03v3 ad=0.3588p pd=1.9u as=0.3588p ps=1.9u w=1.38u l=0.28u
X9 a_492_68# B.t0 a_332_68# VPW.t3 nfet_03v3 ad=0.26p pd=1.52u as=0.26p ps=1.52u w=1u l=0.28u
X10 a_172_440# D.t1 a_28_440# VNW.t5 pfet_03v3 ad=0.3588p pd=1.9u as=0.6072p ps=3.64u w=1.38u l=0.28u
X11 a_332_68# A.t0 a_28_440# VPW.t4 nfet_03v3 ad=0.26p pd=1.52u as=0.26p ps=1.52u w=1u l=0.28u
R0 VSS.n2 VSS.t0 10.9684
R1 VSS.n1 VSS.n0 6.38659
R2 VSS.n1 VSS.t1 5.2398
R3 VSS.n0 VSS.t2 1.6385
R4 VSS.n0 VSS.t3 1.6385
R5 VSS.n2 VSS.n1 0.4805
R6 VSS VSS.n2 0.0485
R7 Y.n2 Y.n1 6.3005
R8 Y.n2 Y.n0 3.03462
R9 Y.n1 Y.t3 1.6385
R10 Y.n1 Y.t2 1.6385
R11 Y.n0 Y.t0 1.31934
R12 Y.n0 Y.t1 1.31934
R13 Y Y.n2 0.0455
R14 VDD.n3 VDD.n0 5.28659
R15 VDD.n2 VDD.n1 5.28659
R16 VDD.n2 VDD.t4 3.57833
R17 VDD.n0 VDD.t0 1.31934
R18 VDD.n0 VDD.t2 1.31934
R19 VDD.n1 VDD.t3 1.31934
R20 VDD.n1 VDD.t1 1.31934
R21 VDD VDD.n3 0.2885
R22 VDD.n3 VDD.n2 0.2405
R23 C.n0 C.t1 26.765
R24 C.n0 C.t0 23.2518
R25 C C.n0 8.05741
R26 B.n0 B.t1 27.2102
R27 B.n0 B.t0 22.8066
R28 B B.n0 8.13443
R29 A.n0 A.t1 26.8541
R30 A.n0 A.t0 23.1627
R31 A A.n0 8.0455
R32 D.n0 D.t1 27.0321
R33 D.n0 D.t0 22.9847
R34 D D.n0 8.04336
R35 VNW.t1 VNW.t2 310.079
R36 VNW.t0 VNW.t1 310.079
R37 VNW.t3 VNW.t0 310.079
R38 VNW.t4 VNW.t3 310.079
R39 VNW.t5 VNW.t4 310.079
R40 VNW VNW.t5 259.69
R41 VPW.t1 VPW.t2 1181.82
R42 VPW.t0 VPW.t1 1181.82
R43 VPW.t3 VPW.t0 1181.82
R44 VPW.t4 VPW.t3 1181.82
R45 VPW.t5 VPW.t4 1181.82
R46 VPW VPW.t5 989.774
C0 B VDD 0.01549f
C1 B a_492_68# 0.00291f
C2 A a_28_440# 0.0423f
C3 A Y 0.00643f
C4 A C 0.00476f
C5 VNW B 0.07402f
C6 A VSS 0.0094f
C7 a_28_440# a_172_440# 0.05447f
C8 Y a_172_440# 0.01294f
C9 A VDD 0.01824f
C10 D B 0.00115f
C11 a_172_440# C 0.00186f
C12 a_172_440# VDD 0.20626f
C13 a_172_440# a_492_68# 0.0014f
C14 A VNW 0.07773f
C15 a_28_440# Y 0.2255f
C16 a_28_440# C 0.15447f
C17 A D 0.17586f
C18 VNW a_172_440# 0.0133f
C19 a_28_440# VSS 0.80062f
C20 Y C 0.01089f
C21 B a_332_68# 0.00161f
C22 Y VSS 0.07495f
C23 a_28_440# VDD 0.14323f
C24 VSS C 0.01181f
C25 D a_172_440# 0.02614f
C26 a_28_440# a_492_68# 0.01582f
C27 Y VDD 0.23069f
C28 C VDD 0.02981f
C29 VSS VDD 0.03106f
C30 VSS a_492_68# 0.00363f
C31 a_28_440# VNW 0.21134f
C32 A a_332_68# 0.00123f
C33 Y VNW 0.03623f
C34 VDD a_492_68# 0
C35 VNW C 0.07452f
C36 a_28_440# D 0.26879f
C37 VSS VNW 0.00679f
C38 Y D 0
C39 a_172_440# a_332_68# 0.00178f
C40 VNW VDD 0.16747f
C41 VSS D 0.01438f
C42 A B 0.09115f
C43 D VDD 0.02601f
C44 a_28_440# a_332_68# 0.01647f
C45 B a_172_440# 0.03867f
C46 VNW D 0.08301f
C47 VSS a_332_68# 0.00349f
C48 a_28_440# B 0.09308f
C49 A a_172_440# 0.07342f
C50 Y B 0.00162f
C51 B C 0.08927f
C52 VSS B 0.01056f
C53 VSS VPW 0.44767f
C54 Y VPW 0.03576f
C55 VDD VPW 0.38614f
C56 C VPW 0.15123f
C57 B VPW 0.21779f
C58 A VPW 0.23598f
C59 D VPW 0.28915f
C60 VNW VPW 2.09393f
C61 a_172_440# VPW 0.0041f
C62 a_28_440# VPW 0.32257f
C63 VNW.t2 VPW 0.19705f
C64 VNW.t1 VPW 0.09219f
C65 VNW.t0 VPW 0.09219f
C66 VNW.t3 VPW 0.09219f
C67 VNW.t4 VPW 0.09219f
C68 VNW.t5 VPW 0.0847f
C69 D.t1 VPW 0.13963f
C70 D.t0 VPW 0.1023f
C71 D.n0 VPW 0.17664f
C72 A.t1 VPW 0.1168f
C73 A.t0 VPW 0.08649f
C74 A.n0 VPW 0.14843f
C75 B.t1 VPW 0.09877f
C76 B.t0 VPW 0.0716f
C77 B.n0 VPW 0.12512f
C78 C.t1 VPW 0.10348f
C79 C.t0 VPW 0.07703f
C80 C.n0 VPW 0.1315f
C81 VDD.t0 VPW 0.02635f
C82 VDD.t2 VPW 0.02635f
C83 VDD.n0 VPW 0.05285f
C84 VDD.t3 VPW 0.02635f
C85 VDD.t1 VPW 0.02635f
C86 VDD.n1 VPW 0.05285f
C87 VDD.t4 VPW 0.07975f
C88 VDD.n2 VPW 0.32488f
C89 VDD.n3 VPW 0.16811f
C90 Y.t0 VPW 0.05238f
C91 Y.t1 VPW 0.05238f
C92 Y.n0 VPW 0.12479f
C93 Y.t3 VPW 0.03796f
C94 Y.t2 VPW 0.03796f
C95 Y.n1 VPW 0.07591f
C96 Y.n2 VPW 0.20978f
C97 VSS.t0 VPW 0.07047f
C98 VSS.t2 VPW 0.02424f
C99 VSS.t3 VPW 0.02424f
C100 VSS.n0 VPW 0.04863f
C101 VSS.t1 VPW 0.074f
C102 VSS.n1 VPW 0.48209f
C103 VSS.n2 VPW 0.22514f
.ends

* NGSPICE file created from gf180mcu_as_sc_mcu7t3v3__ao31_4.ext - technology: gf180mcuD

.subckt gf180mcu_as_sc_mcu7t3v3__ao31_4 VDD VNW VPW VSS D A B C Y
X0 VSS.t2 a_28_440# Y.t3 VPW.t2 nfet_03v3 ad=0.26p pd=1.52u as=0.26p ps=1.52u w=1u l=0.28u
X1 VDD.t4 A.t1 a_172_440# VNW.t6 pfet_03v3 ad=0.3588p pd=1.9u as=0.3588p ps=1.9u w=1.38u l=0.28u
X2 Y.t7 a_28_440# VDD.t0 VNW.t1 pfet_03v3 ad=0.3588p pd=1.9u as=0.3588p ps=1.9u w=1.38u l=0.28u
X3 a_28_440# D.t0 VSS.t0 VPW.t7 nfet_03v3 ad=0.26p pd=1.52u as=0.44p ps=2.88u w=1u l=0.28u
X4 VDD.t3 a_28_440# Y.t0 VNW.t4 pfet_03v3 ad=0.6072p pd=3.64u as=0.3588p ps=1.9u w=1.38u l=0.28u
X5 Y.t2 a_28_440# VSS.t3 VPW.t1 nfet_03v3 ad=0.26p pd=1.52u as=0.26p ps=1.52u w=1u l=0.28u
X6 a_172_440# B.t1 VDD.t6 VNW.t5 pfet_03v3 ad=0.3588p pd=1.9u as=0.3588p ps=1.9u w=1.38u l=0.28u
X7 VDD.t1 a_28_440# Y.t1 VNW.t2 pfet_03v3 ad=0.3588p pd=1.9u as=0.3588p ps=1.9u w=1.38u l=0.28u
X8 VSS.t5 C.t0 a_492_68# VPW.t0 nfet_03v3 ad=0.26p pd=1.52u as=0.26p ps=1.52u w=1u l=0.28u
X9 VSS.t4 a_28_440# Y.t5 VPW.t4 nfet_03v3 ad=0.44p pd=2.88u as=0.26p ps=1.52u w=1u l=0.28u
X10 VDD.t5 C.t1 a_172_440# VNW.t0 pfet_03v3 ad=0.3588p pd=1.9u as=0.3588p ps=1.9u w=1.38u l=0.28u
X11 a_492_68# B.t0 a_332_68# VPW.t5 nfet_03v3 ad=0.26p pd=1.52u as=0.26p ps=1.52u w=1u l=0.28u
X12 Y.t6 a_28_440# VDD.t2 VNW.t3 pfet_03v3 ad=0.3588p pd=1.9u as=0.3588p ps=1.9u w=1.38u l=0.28u
X13 Y.t4 a_28_440# VSS.t1 VPW.t3 nfet_03v3 ad=0.26p pd=1.52u as=0.26p ps=1.52u w=1u l=0.28u
X14 a_172_440# D.t1 a_28_440# VNW.t7 pfet_03v3 ad=0.3588p pd=1.9u as=0.6072p ps=3.64u w=1.38u l=0.28u
X15 a_332_68# A.t0 a_28_440# VPW.t6 nfet_03v3 ad=0.26p pd=1.52u as=0.26p ps=1.52u w=1u l=0.28u
R0 VSS.n4 VSS.t0 10.9684
R1 VSS.n3 VSS.n0 6.38659
R2 VSS.n2 VSS.t4 5.2398
R3 VSS.n2 VSS.n1 3.3618
R4 VSS.n1 VSS.t1 1.6385
R5 VSS.n1 VSS.t2 1.6385
R6 VSS.n0 VSS.t3 1.6385
R7 VSS.n0 VSS.t5 1.6385
R8 VSS.n4 VSS.n3 0.4805
R9 VSS.n3 VSS.n2 0.2405
R10 VSS VSS.n4 0.0485
R11 Y.n7 Y.n6 6.3005
R12 Y.n3 Y.n2 6.3005
R13 Y.n5 Y.n0 2.86653
R14 Y.n4 Y.n1 2.86653
R15 Y.n2 Y.t5 1.6385
R16 Y.n2 Y.t4 1.6385
R17 Y.n6 Y.t3 1.6385
R18 Y.n6 Y.t2 1.6385
R19 Y.n1 Y.t0 1.31934
R20 Y.n1 Y.t6 1.31934
R21 Y.n0 Y.t1 1.31934
R22 Y.n0 Y.t7 1.31934
R23 Y.n5 Y.n4 0.493543
R24 Y.n7 Y.n5 0.168588
R25 Y.n4 Y.n3 0.168588
R26 Y Y.n7 0.0455
R27 Y.n3 Y 0.0455
R28 VDD.n5 VDD.n0 5.28659
R29 VDD.n4 VDD.n1 5.28659
R30 VDD.n3 VDD.t3 3.57833
R31 VDD.n3 VDD.n2 2.01949
R32 VDD.n0 VDD.t6 1.31934
R33 VDD.n0 VDD.t4 1.31934
R34 VDD.n1 VDD.t0 1.31934
R35 VDD.n1 VDD.t5 1.31934
R36 VDD.n2 VDD.t2 1.31934
R37 VDD.n2 VDD.t1 1.31934
R38 VDD VDD.n5 0.2885
R39 VDD.n4 VDD.n3 0.2405
R40 VDD.n5 VDD.n4 0.2405
R41 C.n0 C.t1 26.765
R42 C.n0 C.t0 23.2518
R43 C C.n0 8.05741
R44 B.n0 B.t1 27.2102
R45 B.n0 B.t0 22.8066
R46 B B.n0 8.13443
R47 A.n0 A.t1 26.8541
R48 A.n0 A.t0 23.1627
R49 A A.n0 8.0455
R50 D.n0 D.t1 27.0321
R51 D.n0 D.t0 22.9847
R52 D D.n0 8.04336
R53 VNW.t3 VNW.t4 310.079
R54 VNW.t2 VNW.t3 310.079
R55 VNW.t1 VNW.t2 310.079
R56 VNW.t0 VNW.t1 310.079
R57 VNW.t5 VNW.t0 310.079
R58 VNW.t6 VNW.t5 310.079
R59 VNW.t7 VNW.t6 310.079
R60 VNW VNW.t7 259.69
R61 VPW.t3 VPW.t4 1181.82
R62 VPW.t2 VPW.t3 1181.82
R63 VPW.t1 VPW.t2 1181.82
R64 VPW.t0 VPW.t1 1181.82
R65 VPW.t5 VPW.t0 1181.82
R66 VPW.t6 VPW.t5 1181.82
R67 VPW.t7 VPW.t6 1181.82
R68 VPW VPW.t7 989.774
C0 Y VSS 0.25314f
C1 Y a_28_440# 0.32864f
C2 Y VNW 0.05603f
C3 Y B 0.00162f
C4 VSS a_28_440# 0.85448f
C5 Y A 0.00643f
C6 VNW VSS 0.00756f
C7 Y D 0
C8 Y C 0.01089f
C9 Y VDD 0.60957f
C10 Y a_172_440# 0.01294f
C11 VNW a_28_440# 0.38712f
C12 a_492_68# VSS 0.00363f
C13 B VSS 0.01056f
C14 VSS A 0.0094f
C15 a_492_68# a_28_440# 0.01582f
C16 B a_28_440# 0.09308f
C17 VSS D 0.01438f
C18 C VSS 0.01181f
C19 VDD VSS 0.03205f
C20 VNW B 0.07402f
C21 a_28_440# A 0.0423f
C22 VNW A 0.07773f
C23 D a_28_440# 0.26879f
C24 C a_28_440# 0.15447f
C25 VDD a_28_440# 0.20092f
C26 VNW D 0.08301f
C27 VNW C 0.07452f
C28 a_28_440# a_172_440# 0.05447f
C29 VNW VDD 0.22486f
C30 B a_492_68# 0.00291f
C31 VNW a_172_440# 0.0133f
C32 B A 0.09115f
C33 a_332_68# VSS 0.00349f
C34 B D 0.00115f
C35 B C 0.08927f
C36 a_492_68# VDD 0
C37 B VDD 0.01549f
C38 a_492_68# a_172_440# 0.0014f
C39 D A 0.17586f
C40 C A 0.00476f
C41 B a_172_440# 0.03867f
C42 a_332_68# a_28_440# 0.01647f
C43 VDD A 0.01824f
C44 A a_172_440# 0.07342f
C45 VDD D 0.02601f
C46 C VDD 0.02981f
C47 D a_172_440# 0.02614f
C48 C a_172_440# 0.00186f
C49 VDD a_172_440# 0.20626f
C50 B a_332_68# 0.00161f
C51 a_332_68# A 0.00123f
C52 a_332_68# a_172_440# 0.00178f
C53 VSS VPW 0.54515f
C54 Y VPW 0.05684f
C55 VDD VPW 0.46229f
C56 C VPW 0.15123f
C57 B VPW 0.21779f
C58 A VPW 0.23598f
C59 D VPW 0.28915f
C60 VNW VPW 2.62008f
C61 a_172_440# VPW 0.0041f
C62 a_28_440# VPW 0.53435f
C63 VNW.t4 VPW 0.21949f
C64 VNW.t3 VPW 0.0981f
C65 VNW.t2 VPW 0.0981f
C66 VNW.t1 VPW 0.0981f
C67 VNW.t0 VPW 0.0981f
C68 VNW.t5 VPW 0.0981f
C69 VNW.t6 VPW 0.0981f
C70 VNW.t7 VPW 0.09013f
C71 D.t1 VPW 0.13963f
C72 D.t0 VPW 0.1023f
C73 D.n0 VPW 0.17664f
C74 A.t1 VPW 0.1168f
C75 A.t0 VPW 0.08649f
C76 A.n0 VPW 0.14843f
C77 B.t1 VPW 0.09877f
C78 B.t0 VPW 0.0716f
C79 B.n0 VPW 0.12512f
C80 C.t1 VPW 0.10348f
C81 C.t0 VPW 0.07703f
C82 C.n0 VPW 0.1315f
C83 VDD.t6 VPW 0.03069f
C84 VDD.t4 VPW 0.03069f
C85 VDD.n0 VPW 0.06156f
C86 VDD.t0 VPW 0.03069f
C87 VDD.t5 VPW 0.03069f
C88 VDD.n1 VPW 0.06156f
C89 VDD.t2 VPW 0.03069f
C90 VDD.t1 VPW 0.03069f
C91 VDD.n2 VPW 0.06736f
C92 VDD.t3 VPW 0.09344f
C93 VDD.n3 VPW 0.42158f
C94 VDD.n4 VPW 0.17939f
C95 VDD.n5 VPW 0.19581f
C96 Y.t1 VPW 0.05221f
C97 Y.t7 VPW 0.05221f
C98 Y.n0 VPW 0.11445f
C99 Y.t0 VPW 0.05221f
C100 Y.t6 VPW 0.05221f
C101 Y.n1 VPW 0.11445f
C102 Y.t5 VPW 0.03783f
C103 Y.t4 VPW 0.03783f
C104 Y.n2 VPW 0.07566f
C105 Y.n3 VPW 0.03983f
C106 Y.n4 VPW 0.22137f
C107 Y.n5 VPW 0.22137f
C108 Y.t3 VPW 0.03783f
C109 Y.t2 VPW 0.03783f
C110 Y.n6 VPW 0.07566f
C111 Y.n7 VPW 0.03983f
C112 VSS.t0 VPW 0.06521f
C113 VSS.t3 VPW 0.02242f
C114 VSS.t5 VPW 0.02242f
C115 VSS.n0 VPW 0.045f
C116 VSS.t1 VPW 0.02242f
C117 VSS.t2 VPW 0.02242f
C118 VSS.n1 VPW 0.04684f
C119 VSS.t4 VPW 0.06885f
C120 VSS.n2 VPW 0.39631f
C121 VSS.n3 VPW 0.26372f
C122 VSS.n4 VPW 0.20832f
.ends

* NGSPICE file created from gf180mcu_as_sc_mcu7t3v3__aoi211_2.ext - technology: gf180mcuD

.subckt gf180mcu_as_sc_mcu7t3v3__aoi211_2 VDD VNW VPW VSS A B C Y D
X0 VDD.t2 A.t2 a_172_440# VNW.t7 pfet_03v3 ad=0.3588p pd=1.9u as=0.3588p ps=1.9u w=1.38u l=0.28u
X1 Y.t2 D.t1 VSS.t2 VPW.t0 nfet_03v3 ad=0.26p pd=1.52u as=0.26p ps=1.52u w=1u l=0.28u
X2 VSS.t0 A.t1 a_28_68# VPW.t6 nfet_03v3 ad=0.26p pd=1.52u as=0.44p ps=2.88u w=1u l=0.28u
X3 a_796_440# C.t2 a_172_440# VNW.t3 pfet_03v3 ad=0.3588p pd=1.9u as=0.3588p ps=1.9u w=1.38u l=0.28u
X4 VSS.t1 C.t0 Y.t0 VPW.t3 nfet_03v3 ad=0.26p pd=1.52u as=0.26p ps=1.52u w=1u l=0.28u
X5 a_172_440# B.t3 VDD.t1 VNW.t4 pfet_03v3 ad=0.3588p pd=1.9u as=0.3588p ps=1.9u w=1.38u l=0.28u
X6 a_28_68# B.t0 Y.t3 VPW.t5 nfet_03v3 ad=0.44p pd=2.88u as=0.26p ps=1.52u w=1u l=0.28u
X7 Y.t4 D.t3 a_796_440# VNW.t0 pfet_03v3 ad=0.3588p pd=1.9u as=0.3588p ps=1.9u w=1.38u l=0.28u
X8 VDD.t0 B.t2 a_172_440# VNW.t5 pfet_03v3 ad=0.6072p pd=3.64u as=0.3588p ps=1.9u w=1.38u l=0.28u
X9 a_172_440# C.t3 a_796_440# VNW.t2 pfet_03v3 ad=0.3588p pd=1.9u as=0.6072p ps=3.64u w=1.38u l=0.28u
X10 Y.t5 C.t1 VSS.t4 VPW.t2 nfet_03v3 ad=0.26p pd=1.52u as=0.44p ps=2.88u w=1u l=0.28u
X11 Y.t6 B.t1 a_28_68# VPW.t4 nfet_03v3 ad=0.26p pd=1.52u as=0.26p ps=1.52u w=1u l=0.28u
X12 a_796_440# D.t2 Y.t1 VNW.t1 pfet_03v3 ad=0.6417p pd=3.69u as=0.3588p ps=1.9u w=1.38u l=0.28u
X13 a_172_440# A.t3 VDD.t3 VNW.t6 pfet_03v3 ad=0.3588p pd=1.9u as=0.6072p ps=3.64u w=1.38u l=0.28u
X14 VSS.t5 D.t0 Y.t7 VPW.t1 nfet_03v3 ad=0.465p pd=2.93u as=0.26p ps=1.52u w=1u l=0.28u
X15 a_28_68# A.t0 VSS.t3 VPW.t7 nfet_03v3 ad=0.26p pd=1.52u as=0.26p ps=1.52u w=1u l=0.28u
R0 VSS.n3 VSS.t4 10.9684
R1 VSS.n2 VSS.t5 10.9621
R2 VSS.n2 VSS.n1 6.38659
R3 VSS.n4 VSS.n0 6.38659
R4 VSS.n1 VSS.t2 1.6385
R5 VSS.n1 VSS.t1 1.6385
R6 VSS.n0 VSS.t3 1.6385
R7 VSS.n0 VSS.t0 1.6385
R8 VSS.n4 VSS.n3 0.4565
R9 VSS.n3 VSS.n2 0.2405
R10 VSS VSS.n4 0.1685
R11 Y.n2 Y.n1 7.17702
R12 Y.n5 Y.n3 6.61159
R13 Y.n2 Y.n0 6.45507
R14 Y.n5 Y.n4 5.68208
R15 Y.n3 Y.t7 1.6385
R16 Y.n3 Y.t2 1.6385
R17 Y.n1 Y.t3 1.6385
R18 Y.n1 Y.t6 1.6385
R19 Y.n0 Y.t0 1.6385
R20 Y.n0 Y.t5 1.6385
R21 Y.n4 Y.t1 1.31934
R22 Y.n4 Y.t4 1.31934
R23 Y.n5 Y.n2 0.303761
R24 Y Y.n5 0.0237941
R25 VDD.n1 VDD.t0 13.6402
R26 VDD.n1 VDD.n0 5.28659
R27 VDD.n2 VDD.t3 4.18151
R28 VDD.n0 VDD.t1 1.31934
R29 VDD.n0 VDD.t2 1.31934
R30 VDD.n2 VDD.n1 0.2405
R31 VDD VDD.n2 0.0485
R32 D.n0 D.t3 28.6791
R33 D.n1 D.t2 25.3351
R34 D.n0 D.t1 24.7684
R35 D.n2 D.t0 21.6953
R36 D.n1 D.n0 14.6005
R37 D D.n2 8.04597
R38 D.n2 D.n1 0.0639783
R39 C.n0 C.t2 24.5076
R40 C.n1 C.t3 24.5076
R41 C.n0 C.t0 19.5541
R42 C.n1 C.t1 19.5541
R43 C.n2 C.n0 11.6602
R44 C.n2 C.n1 4.563
R45 C C.n2 4.13421
R46 B.n0 B.t2 22.5523
R47 B.n1 B.t3 22.5523
R48 B.n0 B.t0 19.6844
R49 B.n1 B.t1 19.6844
R50 B.n2 B.n0 7.21562
R51 B.n2 B.n1 6.36678
R52 B B.n2 4.11771
R53 A.n2 A.t3 25.2723
R54 A.n0 A.t2 25.1594
R55 A.n1 A.t1 21.6667
R56 A.n0 A.t0 19.0326
R57 A.n1 A.n0 13.5723
R58 A A.n2 8.06141
R59 A.n2 A.n1 1.05411
R60 VNW.t5 VNW.t2 558.14
R61 VNW.t0 VNW.t1 310.079
R62 VNW.t3 VNW.t0 310.079
R63 VNW.t2 VNW.t3 310.079
R64 VNW.t4 VNW.t5 310.079
R65 VNW.t7 VNW.t4 310.079
R66 VNW.t6 VNW.t7 310.079
R67 VNW VNW.t6 259.69
R68 VPW.t5 VPW.t2 2127.27
R69 VPW.t0 VPW.t1 1181.82
R70 VPW.t3 VPW.t0 1181.82
R71 VPW.t2 VPW.t3 1181.82
R72 VPW.t4 VPW.t5 1181.82
R73 VPW.t7 VPW.t4 1181.82
R74 VPW.t6 VPW.t7 1181.82
R75 VPW VPW.t6 989.774
C0 B VNW 0.16924f
C1 B Y 0.13564f
C2 VDD C 0.01934f
C3 VDD VSS 0.00705f
C4 VDD a_172_440# 0.25965f
C5 a_796_440# D 0.05088f
C6 VNW C 0.17449f
C7 VNW VSS 0.00483f
C8 VNW a_172_440# 0.03143f
C9 C Y 0.27086f
C10 VSS Y 0.37106f
C11 a_172_440# Y 0.05758f
C12 a_796_440# A 0
C13 a_28_68# A 0.11303f
C14 B A 0.05139f
C15 C D 0.0307f
C16 VNW VDD 0.22019f
C17 D VSS 0.06522f
C18 B a_796_440# 0
C19 B a_28_68# 0.04889f
C20 VDD Y 0.00698f
C21 A C 0
C22 VNW Y 0.03154f
C23 A VSS 0.03042f
C24 A a_172_440# 0.02395f
C25 a_796_440# C 0.02745f
C26 a_796_440# VSS 0.0031f
C27 a_28_68# C 0
C28 a_28_68# VSS 0.62496f
C29 a_796_440# a_172_440# 0.19721f
C30 a_28_68# a_172_440# 0.04232f
C31 VDD D 0.01772f
C32 B C 0.02837f
C33 B VSS 0.02045f
C34 B a_172_440# 0.13651f
C35 VNW D 0.1853f
C36 A VDD 0.09117f
C37 D Y 0.10047f
C38 a_796_440# VDD 0.82794f
C39 C VSS 0.03349f
C40 a_28_68# VDD 0.00606f
C41 C a_172_440# 0.07441f
C42 a_172_440# VSS 0
C43 VNW A 0.1798f
C44 A Y 0.0019f
C45 VNW a_796_440# 0.01467f
C46 VNW a_28_68# 0.00442f
C47 a_796_440# Y 0.20073f
C48 a_28_68# Y 0.21607f
C49 B VDD 0.03661f
C50 VSS VPW 0.58485f
C51 Y VPW 0.08714f
C52 VDD VPW 0.4006f
C53 D VPW 0.31233f
C54 C VPW 0.30916f
C55 B VPW 0.32402f
C56 A VPW 0.30862f
C57 VNW VPW 2.78869f
C58 a_28_68# VPW 0.02698f
C59 a_796_440# VPW 0.00794f
C60 a_172_440# VPW 0.00805f
C61 VNW.t1 VPW 0.19968f
C62 VNW.t0 VPW 0.09342f
C63 VNW.t3 VPW 0.09342f
C64 VNW.t2 VPW 0.13078f
C65 VNW.t5 VPW 0.13078f
C66 VNW.t4 VPW 0.09342f
C67 VNW.t7 VPW 0.09342f
C68 VNW.t6 VPW 0.08583f
C69 A.t3 VPW 0.06279f
C70 A.t2 VPW 0.06126f
C71 A.t0 VPW 0.04149f
C72 A.n0 VPW 0.09284f
C73 A.t1 VPW 0.04553f
C74 A.n1 VPW 0.06974f
C75 A.n2 VPW 0.05261f
C76 B.t2 VPW 0.0697f
C77 B.t0 VPW 0.05078f
C78 B.n0 VPW 0.10436f
C79 B.t3 VPW 0.0697f
C80 B.t1 VPW 0.05078f
C81 B.n1 VPW 0.10673f
C82 B.n2 VPW 0.05014f
C83 C.t2 VPW 0.08068f
C84 C.t0 VPW 0.05622f
C85 C.n0 VPW 0.11971f
C86 C.t3 VPW 0.08068f
C87 C.t1 VPW 0.05622f
C88 C.n1 VPW 0.1175f
C89 C.n2 VPW 0.04662f
C90 D.t3 VPW 0.05976f
C91 D.t1 VPW 0.04423f
C92 D.n0 VPW 0.0742f
C93 D.t2 VPW 0.05744f
C94 D.n1 VPW 0.06442f
C95 D.t0 VPW 0.04208f
C96 D.n2 VPW 0.04386f
C97 VDD.t3 VPW 0.10201f
C98 VDD.t1 VPW 0.03766f
C99 VDD.t2 VPW 0.03766f
C100 VDD.n0 VPW 0.07554f
C101 VDD.t0 VPW 0.11532f
C102 VDD.n1 VPW 0.89596f
C103 VDD.n2 VPW 0.2084f
C104 Y.t0 VPW 0.04282f
C105 Y.t5 VPW 0.04282f
C106 Y.n0 VPW 0.08631f
C107 Y.t3 VPW 0.04282f
C108 Y.t6 VPW 0.04282f
C109 Y.n1 VPW 0.09592f
C110 Y.n2 VPW 0.23018f
C111 Y.t7 VPW 0.04282f
C112 Y.t2 VPW 0.04282f
C113 Y.n3 VPW 0.08788f
C114 Y.t1 VPW 0.0591f
C115 Y.t4 VPW 0.0591f
C116 Y.n4 VPW 0.1285f
C117 Y.n5 VPW 0.38052f
C118 VSS.t3 VPW 0.02154f
C119 VSS.t0 VPW 0.02154f
C120 VSS.n0 VPW 0.04323f
C121 VSS.t4 VPW 0.06264f
C122 VSS.t2 VPW 0.02154f
C123 VSS.t1 VPW 0.02154f
C124 VSS.n1 VPW 0.04323f
C125 VSS.t5 VPW 0.06989f
C126 VSS.n2 VPW 0.32311f
C127 VSS.n3 VPW 0.25582f
C128 VSS.n4 VPW 0.22154f
.ends

* NGSPICE file created from gf180mcu_as_sc_mcu7t3v3__aoi211_4.ext - technology: gf180mcuD

.subckt gf180mcu_as_sc_mcu7t3v3__aoi211_4 VDD VNW VPW VSS A B C D Y
X0 Y.t13 B.t1 a_172_68# VPW.t10 nfet_03v3 ad=0.26p pd=1.52u as=0.26p ps=1.52u w=1u l=0.28u
X1 a_28_440# A.t6 VDD.t7 VNW.t13 pfet_03v3 ad=0.3588p pd=1.9u as=0.3588p ps=1.9u w=1.38u l=0.28u
X2 VDD.t5 B.t6 a_28_440# VNW.t9 pfet_03v3 ad=0.3588p pd=1.9u as=0.3588p ps=1.9u w=1.38u l=0.28u
X3 a_172_68# A.t3 VSS.t7 VPW.t12 nfet_03v3 ad=0.26p pd=1.52u as=0.44p ps=2.88u w=1u l=0.28u
X4 a_2412_440# D.t4 Y.t0 VNW.t3 pfet_03v3 ad=0.3588p pd=1.9u as=0.3588p ps=1.9u w=1.38u l=0.28u
X5 VSS.t9 C.t2 Y.t12 VPW.t5 nfet_03v3 ad=0.26p pd=1.52u as=0.26p ps=1.52u w=1u l=0.28u
X6 VSS.t8 C.t0 Y.t9 VPW.t7 nfet_03v3 ad=0.44p pd=2.88u as=0.26p ps=1.52u w=1u l=0.28u
X7 a_28_440# A.t4 VDD.t4 VNW.t15 pfet_03v3 ad=0.3588p pd=1.9u as=0.3588p ps=1.9u w=1.38u l=0.28u
X8 a_1772_440# C.t5 a_28_440# VNW.t6 pfet_03v3 ad=0.3588p pd=1.9u as=0.3588p ps=1.9u w=1.38u l=0.28u
X9 a_172_68# B.t2 Y.t4 VPW.t9 nfet_03v3 ad=0.26p pd=1.52u as=0.26p ps=1.52u w=1u l=0.28u
X10 a_1452_440# C.t7 a_28_440# VNW.t4 pfet_03v3 ad=0.3588p pd=1.9u as=0.3588p ps=1.9u w=1.38u l=0.28u
X11 Y.t10 D.t7 a_1772_440# VNW.t0 pfet_03v3 ad=0.3588p pd=1.9u as=0.3588p ps=1.9u w=1.38u l=0.28u
X12 Y.t14 C.t3 VSS.t10 VPW.t4 nfet_03v3 ad=0.26p pd=1.52u as=0.26p ps=1.52u w=1u l=0.28u
X13 Y.t1 D.t0 VSS.t0 VPW.t3 nfet_03v3 ad=0.26p pd=1.52u as=0.26p ps=1.52u w=1u l=0.28u
X14 VDD.t0 A.t5 a_28_440# VNW.t14 pfet_03v3 ad=0.3588p pd=1.9u as=0.3588p ps=1.9u w=1.38u l=0.28u
X15 a_28_440# B.t5 VDD.t2 VNW.t10 pfet_03v3 ad=0.3588p pd=1.9u as=0.3588p ps=1.9u w=1.38u l=0.28u
X16 Y.t3 B.t3 a_172_68# VPW.t8 nfet_03v3 ad=0.26p pd=1.52u as=0.26p ps=1.52u w=1u l=0.28u
X17 a_1452_440# D.t6 Y.t6 VNW.t1 pfet_03v3 ad=0.3588p pd=1.9u as=0.3588p ps=1.9u w=1.38u l=0.28u
X18 a_28_440# C.t4 a_2412_440# VNW.t7 pfet_03v3 ad=0.6072p pd=3.64u as=0.3588p ps=1.9u w=1.38u l=0.28u
X19 VSS.t6 A.t0 a_172_68# VPW.t15 nfet_03v3 ad=0.26p pd=1.52u as=0.26p ps=1.52u w=1u l=0.28u
X20 VSS.t4 D.t1 Y.t8 VPW.t2 nfet_03v3 ad=0.26p pd=1.52u as=0.26p ps=1.52u w=1u l=0.28u
X21 a_28_440# B.t7 VDD.t6 VNW.t8 pfet_03v3 ad=0.3588p pd=1.9u as=0.3588p ps=1.9u w=1.38u l=0.28u
X22 Y.t11 D.t5 a_1452_440# VNW.t2 pfet_03v3 ad=0.3588p pd=1.9u as=0.3588p ps=1.9u w=1.38u l=0.28u
X23 a_172_68# A.t1 VSS.t5 VPW.t14 nfet_03v3 ad=0.26p pd=1.52u as=0.26p ps=1.52u w=1u l=0.28u
X24 VSS.t1 D.t3 Y.t2 VPW.t0 nfet_03v3 ad=0.26p pd=1.52u as=0.26p ps=1.52u w=1u l=0.28u
X25 VDD.t1 B.t4 a_28_440# VNW.t11 pfet_03v3 ad=0.3588p pd=1.9u as=0.3588p ps=1.9u w=1.38u l=0.28u
X26 a_28_440# C.t6 a_1452_440# VNW.t5 pfet_03v3 ad=0.3588p pd=1.9u as=0.3588p ps=1.9u w=1.38u l=0.28u
X27 a_172_68# B.t0 Y.t7 VPW.t11 nfet_03v3 ad=0.26p pd=1.52u as=0.26p ps=1.52u w=1u l=0.28u
X28 Y.t5 D.t2 VSS.t2 VPW.t1 nfet_03v3 ad=0.26p pd=1.52u as=0.26p ps=1.52u w=1u l=0.28u
X29 VDD.t3 A.t7 a_28_440# VNW.t12 pfet_03v3 ad=0.3588p pd=1.9u as=0.6072p ps=3.64u w=1.38u l=0.28u
X30 VSS.t3 A.t2 a_172_68# VPW.t13 nfet_03v3 ad=0.26p pd=1.52u as=0.26p ps=1.52u w=1u l=0.28u
X31 Y.t15 C.t1 VSS.t11 VPW.t6 nfet_03v3 ad=0.26p pd=1.52u as=0.26p ps=1.52u w=1u l=0.28u
R0 VSS.n5 VSS.t8 11.2084
R1 VSS.n10 VSS.t7 10.9684
R2 VSS.n5 VSS.n4 6.38659
R3 VSS.n6 VSS.n3 6.38659
R4 VSS.n7 VSS.n2 6.38659
R5 VSS.n8 VSS.n1 6.38659
R6 VSS.n9 VSS.n0 6.38659
R7 VSS.n4 VSS.t0 1.6385
R8 VSS.n4 VSS.t4 1.6385
R9 VSS.n3 VSS.t2 1.6385
R10 VSS.n3 VSS.t1 1.6385
R11 VSS.n2 VSS.t11 1.6385
R12 VSS.n2 VSS.t9 1.6385
R13 VSS.n1 VSS.t10 1.6385
R14 VSS.n1 VSS.t6 1.6385
R15 VSS.n0 VSS.t5 1.6385
R16 VSS.n0 VSS.t3 1.6385
R17 VSS.n9 VSS.n8 0.7205
R18 VSS.n6 VSS.n5 0.2405
R19 VSS.n7 VSS.n6 0.2405
R20 VSS.n8 VSS.n7 0.2405
R21 VSS.n10 VSS.n9 0.2405
R22 VSS VSS.n10 0.0485
R23 Y.n2 Y.n0 6.92659
R24 Y.n10 Y.n9 6.3005
R25 Y.n8 Y.n7 6.3005
R26 Y.n6 Y.n5 6.3005
R27 Y.n4 Y.n3 6.3005
R28 Y.n2 Y.n1 6.3005
R29 Y.n13 Y.n11 5.82659
R30 Y.n13 Y.n12 5.2005
R31 Y.n0 Y.t4 1.6385
R32 Y.n0 Y.t3 1.6385
R33 Y.n1 Y.t7 1.6385
R34 Y.n1 Y.t13 1.6385
R35 Y.n3 Y.t12 1.6385
R36 Y.n3 Y.t14 1.6385
R37 Y.n5 Y.t2 1.6385
R38 Y.n5 Y.t15 1.6385
R39 Y.n7 Y.t8 1.6385
R40 Y.n7 Y.t5 1.6385
R41 Y.n9 Y.t9 1.6385
R42 Y.n9 Y.t1 1.6385
R43 Y.n11 Y.t6 1.31934
R44 Y.n11 Y.t10 1.31934
R45 Y.n12 Y.t0 1.31934
R46 Y.n12 Y.t11 1.31934
R47 Y.n14 Y.n13 1.0342
R48 Y.n4 Y.n2 0.93963
R49 Y.n10 Y.n8 0.626587
R50 Y.n8 Y.n6 0.626587
R51 Y.n6 Y.n4 0.626587
R52 Y.n14 Y.n10 0.317457
R53 Y Y.n14 0.0305
R54 VDD.n4 VDD.n3 5.52659
R55 VDD.n6 VDD.n0 5.28659
R56 VDD.n5 VDD.n1 5.28659
R57 VDD.n4 VDD.n2 5.28659
R58 VDD.n0 VDD.t7 1.31934
R59 VDD.n0 VDD.t3 1.31934
R60 VDD.n1 VDD.t6 1.31934
R61 VDD.n1 VDD.t0 1.31934
R62 VDD.n2 VDD.t2 1.31934
R63 VDD.n2 VDD.t5 1.31934
R64 VDD.n3 VDD.t4 1.31934
R65 VDD.n3 VDD.t1 1.31934
R66 VDD.n5 VDD.n4 0.2405
R67 VDD.n6 VDD.n5 0.2405
R68 VDD VDD.n6 0.1685
R69 D.n0 D.t4 24.2469
R70 D.n1 D.t5 24.2469
R71 D.n3 D.t6 24.2469
R72 D.n2 D.t7 24.2469
R73 D.n0 D.t0 19.8148
R74 D.n1 D.t1 19.8148
R75 D.n3 D.t2 19.8148
R76 D.n2 D.t3 19.8148
R77 D.n1 D.n0 16.2227
R78 D.n3 D.n2 16.2227
R79 D.n4 D.n1 8.31439
R80 D.n4 D.n3 7.90883
R81 D D.n4 1.95256
R82 C.n0 C.t4 28.317
R83 C.n3 C.t6 24.3773
R84 C.n1 C.t5 24.3773
R85 C.n2 C.t7 24.3773
R86 C.n0 C.t0 23.1027
R87 C.n3 C.t2 18.9023
R88 C.n1 C.t1 18.9023
R89 C.n2 C.t3 18.9023
R90 C.n4 C.n0 18.7004
R91 C.n3 C.n1 14.9749
R92 C.n3 C.n2 14.9749
R93 C.n4 C.n3 2.0005
R94 C C.n4 0.217423
R95 B.n0 B.t4 24.2469
R96 B.n1 B.t5 24.2469
R97 B.n3 B.t6 24.2469
R98 B.n2 B.t7 24.2469
R99 B.n0 B.t0 17.7291
R100 B.n1 B.t1 17.7291
R101 B.n3 B.t2 17.7291
R102 B.n2 B.t3 17.7291
R103 B.n1 B.n0 13.2732
R104 B.n3 B.n2 13.2732
R105 B.n4 B.n1 6.88573
R106 B.n4 B.n3 6.388
R107 B B.n4 1.9024
R108 A.n0 A.t4 28.317
R109 A.n3 A.t6 24.1166
R110 A.n1 A.t5 24.1166
R111 A.n2 A.t7 24.1166
R112 A.n0 A.t0 23.1027
R113 A.n3 A.t2 19.0326
R114 A.n1 A.t1 19.0326
R115 A.n2 A.t3 19.0326
R116 A.n3 A.n1 14.7853
R117 A.n3 A.n2 14.7853
R118 A.n4 A.n0 9.95564
R119 A.n4 A.n3 2.0005
R120 A A.n4 0.212
R121 VNW.t3 VNW.t7 310.079
R122 VNW.t2 VNW.t3 310.079
R123 VNW.t1 VNW.t2 310.079
R124 VNW.t0 VNW.t1 310.079
R125 VNW.t6 VNW.t0 310.079
R126 VNW.t5 VNW.t6 310.079
R127 VNW.t4 VNW.t5 310.079
R128 VNW.t15 VNW.t4 310.079
R129 VNW.t11 VNW.t15 310.079
R130 VNW.t10 VNW.t11 310.079
R131 VNW.t9 VNW.t10 310.079
R132 VNW.t8 VNW.t9 310.079
R133 VNW.t14 VNW.t8 310.079
R134 VNW.t13 VNW.t14 310.079
R135 VNW.t12 VNW.t13 310.079
R136 VNW VNW.t12 259.69
R137 VPW.t3 VPW.t7 1181.82
R138 VPW.t2 VPW.t3 1181.82
R139 VPW.t1 VPW.t2 1181.82
R140 VPW.t0 VPW.t1 1181.82
R141 VPW.t6 VPW.t0 1181.82
R142 VPW.t5 VPW.t6 1181.82
R143 VPW.t4 VPW.t5 1181.82
R144 VPW.t15 VPW.t4 1181.82
R145 VPW.t11 VPW.t15 1181.82
R146 VPW.t10 VPW.t11 1181.82
R147 VPW.t9 VPW.t10 1181.82
R148 VPW.t8 VPW.t9 1181.82
R149 VPW.t14 VPW.t8 1181.82
R150 VPW.t13 VPW.t14 1181.82
R151 VPW.t12 VPW.t13 1181.82
R152 VPW VPW.t12 989.774
C0 D Y 0.49267f
C1 A a_1452_440# 0.01046f
C2 a_28_440# Y 0.1818f
C3 VDD D 0.04809f
C4 VDD a_28_440# 1.3583f
C5 B a_28_440# 0.04857f
C6 D VNW 0.33464f
C7 Y a_1452_440# 0.26289f
C8 A Y 0.07394f
C9 a_28_440# VNW 0.05977f
C10 D C 0.19523f
C11 VSS D 0.06881f
C12 a_172_68# D 0
C13 VDD a_1452_440# 0.05075f
C14 A VDD 0.0865f
C15 B a_1452_440# 0
C16 a_28_440# C 0.17981f
C17 A B 0.6776f
C18 VSS a_28_440# 0.01559f
C19 a_1772_440# a_28_440# 0.01098f
C20 VNW a_1452_440# 0.0131f
C21 A VNW 0.35722f
C22 a_2412_440# a_28_440# 0.0098f
C23 VDD Y 0.22638f
C24 C a_1452_440# 0.30534f
C25 A C 0.06936f
C26 a_1772_440# a_1452_440# 0.0128f
C27 VSS A 0.0802f
C28 B Y 0.33958f
C29 a_1772_440# A 0
C30 a_172_68# A 0.21774f
C31 VDD B 0.06385f
C32 VNW Y 0.05519f
C33 a_2412_440# a_1452_440# 0.00117f
C34 A a_2412_440# 0
C35 Y C 0.61708f
C36 VSS Y 0.67426f
C37 VDD VNW 0.31433f
C38 a_1772_440# Y 0.00254f
C39 a_172_68# Y 0.66562f
C40 B VNW 0.33535f
C41 VDD C 0.0447f
C42 VSS VDD 0.00933f
C43 a_1772_440# VDD 0.00881f
C44 B C 0.00285f
C45 a_172_68# VDD 0
C46 a_2412_440# Y 0.01894f
C47 VSS B 0.03798f
C48 a_172_68# B 0.06041f
C49 VDD a_2412_440# 0.00593f
C50 VNW C 0.33446f
C51 VSS VNW 0.00803f
C52 D a_28_440# 0.03848f
C53 a_172_68# VNW 0.00252f
C54 VSS C 0.11712f
C55 a_1772_440# C 0.00176f
C56 a_172_68# C 0.00155f
C57 a_172_68# VSS 1.0043f
C58 a_2412_440# C 0.00185f
C59 D a_1452_440# 0.27313f
C60 A D 0
C61 a_28_440# a_1452_440# 0.14728f
C62 A a_28_440# 0.80184f
C63 VSS VPW 0.89494f
C64 Y VPW 0.11791f
C65 VDD VPW 0.64018f
C66 D VPW 0.64849f
C67 C VPW 0.61397f
C68 B VPW 0.69439f
C69 A VPW 0.50919f
C70 VNW VPW 4.70018f
C71 a_172_68# VPW 0.02103f
C72 a_1452_440# VPW 0.00296f
C73 a_28_440# VPW 0.194f
C74 VNW.t7 VPW 0.25766f
C75 VNW.t3 VPW 0.09769f
C76 VNW.t2 VPW 0.09769f
C77 VNW.t1 VPW 0.09769f
C78 VNW.t0 VPW 0.09769f
C79 VNW.t6 VPW 0.09769f
C80 VNW.t5 VPW 0.09769f
C81 VNW.t4 VPW 0.09769f
C82 VNW.t15 VPW 0.09769f
C83 VNW.t11 VPW 0.09769f
C84 VNW.t10 VPW 0.09769f
C85 VNW.t9 VPW 0.09769f
C86 VNW.t8 VPW 0.09769f
C87 VNW.t14 VPW 0.09769f
C88 VNW.t13 VPW 0.09769f
C89 VNW.t12 VPW 0.08975f
C90 A.t4 VPW 0.12215f
C91 A.t0 VPW 0.08752f
C92 A.n0 VPW 0.19452f
C93 A.t2 VPW 0.07734f
C94 A.t6 VPW 0.11182f
C95 A.t5 VPW 0.11182f
C96 A.t1 VPW 0.07734f
C97 A.n1 VPW 0.19058f
C98 A.t7 VPW 0.11182f
C99 A.t3 VPW 0.07734f
C100 A.n2 VPW 0.19058f
C101 A.n3 VPW 0.23456f
C102 A.n4 VPW 0.70759f
C103 B.t5 VPW 0.08467f
C104 B.t1 VPW 0.05614f
C105 B.t4 VPW 0.08467f
C106 B.t0 VPW 0.05614f
C107 B.n0 VPW 0.14974f
C108 B.n1 VPW 0.15934f
C109 B.t6 VPW 0.08467f
C110 B.t2 VPW 0.05614f
C111 B.t7 VPW 0.08467f
C112 B.t3 VPW 0.05614f
C113 B.n2 VPW 0.14974f
C114 B.n3 VPW 0.15721f
C115 B.n4 VPW 0.0959f
C116 C.t4 VPW 0.08846f
C117 C.t0 VPW 0.06339f
C118 C.n0 VPW 0.26776f
C119 C.t2 VPW 0.0558f
C120 C.t6 VPW 0.08142f
C121 C.t5 VPW 0.08142f
C122 C.t1 VPW 0.0558f
C123 C.n1 VPW 0.1374f
C124 C.t7 VPW 0.08142f
C125 C.t3 VPW 0.0558f
C126 C.n2 VPW 0.1374f
C127 C.n3 VPW 0.16885f
C128 C.n4 VPW 0.53933f
C129 D.t5 VPW 0.08274f
C130 D.t1 VPW 0.05841f
C131 D.t4 VPW 0.08274f
C132 D.t0 VPW 0.05841f
C133 D.n0 VPW 0.13622f
C134 D.n1 VPW 0.14361f
C135 D.t6 VPW 0.08274f
C136 D.t2 VPW 0.05841f
C137 D.t7 VPW 0.08274f
C138 D.t3 VPW 0.05841f
C139 D.n2 VPW 0.13622f
C140 D.n3 VPW 0.14248f
C141 D.n4 VPW 0.08369f
C142 VDD.t7 VPW 0.0342f
C143 VDD.t3 VPW 0.0342f
C144 VDD.n0 VPW 0.0686f
C145 VDD.t6 VPW 0.0342f
C146 VDD.t0 VPW 0.0342f
C147 VDD.n1 VPW 0.0686f
C148 VDD.t2 VPW 0.0342f
C149 VDD.t5 VPW 0.0342f
C150 VDD.n2 VPW 0.0686f
C151 VDD.t4 VPW 0.0342f
C152 VDD.t1 VPW 0.0342f
C153 VDD.n3 VPW 0.11345f
C154 VDD.n4 VPW 1.18773f
C155 VDD.n5 VPW 0.19992f
C156 VDD.n6 VPW 0.17247f
C157 Y.t4 VPW 0.057f
C158 Y.t3 VPW 0.057f
C159 Y.n0 VPW 0.12285f
C160 Y.t7 VPW 0.057f
C161 Y.t13 VPW 0.057f
C162 Y.n1 VPW 0.114f
C163 Y.n2 VPW 0.29068f
C164 Y.t12 VPW 0.057f
C165 Y.t14 VPW 0.057f
C166 Y.n3 VPW 0.114f
C167 Y.n4 VPW 0.2017f
C168 Y.t2 VPW 0.057f
C169 Y.t15 VPW 0.057f
C170 Y.n5 VPW 0.114f
C171 Y.n6 VPW 0.16136f
C172 Y.t8 VPW 0.057f
C173 Y.t5 VPW 0.057f
C174 Y.n7 VPW 0.114f
C175 Y.n8 VPW 0.16136f
C176 Y.t9 VPW 0.057f
C177 Y.t1 VPW 0.057f
C178 Y.n9 VPW 0.114f
C179 Y.n10 VPW 0.12152f
C180 Y.t6 VPW 0.07866f
C181 Y.t10 VPW 0.07866f
C182 Y.n11 VPW 0.16784f
C183 Y.t0 VPW 0.07866f
C184 Y.t11 VPW 0.07866f
C185 Y.n12 VPW 0.15732f
C186 Y.n13 VPW 0.34746f
C187 Y.n14 VPW 0.30144f
C188 VSS.t7 VPW 0.06092f
C189 VSS.t5 VPW 0.02095f
C190 VSS.t3 VPW 0.02095f
C191 VSS.n0 VPW 0.04204f
C192 VSS.t10 VPW 0.02095f
C193 VSS.t6 VPW 0.02095f
C194 VSS.n1 VPW 0.04204f
C195 VSS.t11 VPW 0.02095f
C196 VSS.t9 VPW 0.02095f
C197 VSS.n2 VPW 0.04204f
C198 VSS.t2 VPW 0.02095f
C199 VSS.t1 VPW 0.02095f
C200 VSS.n3 VPW 0.04204f
C201 VSS.t0 VPW 0.02095f
C202 VSS.t4 VPW 0.02095f
C203 VSS.n4 VPW 0.04204f
C204 VSS.t8 VPW 0.06492f
C205 VSS.n5 VPW 0.3519f
C206 VSS.n6 VPW 0.16902f
C207 VSS.n7 VPW 0.16902f
C208 VSS.n8 VPW 0.32372f
C209 VSS.n9 VPW 0.32372f
C210 VSS.n10 VPW 0.11727f
.ends

* NGSPICE file created from gf180mcu_as_sc_mcu7t3v3__aoi21_2.ext - technology: gf180mcuD

.subckt gf180mcu_as_sc_mcu7t3v3__aoi21_2 VDD VNW VPW VSS Y C B A
X0 VSS.t0 C.t0 Y.t0 VPW.t1 nfet_03v3 ad=0.45p pd=2.9u as=0.26p ps=1.52u w=1u l=0.28u
X1 a_28_440# B.t3 VDD.t3 VNW.t2 pfet_03v3 ad=0.3588p pd=1.9u as=0.3588p ps=1.9u w=1.38u l=0.28u
X2 Y.t3 C.t3 a_28_440# VNW.t0 pfet_03v3 ad=0.3588p pd=1.9u as=0.3588p ps=1.9u w=1.38u l=0.28u
X3 a_172_68# A.t1 VSS.t2 VPW.t4 nfet_03v3 ad=0.26p pd=1.52u as=0.44p ps=2.88u w=1u l=0.28u
X4 Y.t2 C.t1 VSS.t1 VPW.t0 nfet_03v3 ad=0.26p pd=1.52u as=0.26p ps=1.52u w=1u l=0.28u
X5 VDD.t2 B.t2 a_28_440# VNW.t3 pfet_03v3 ad=0.3588p pd=1.9u as=0.3588p ps=1.9u w=1.38u l=0.28u
X6 a_28_440# C.t2 Y.t4 VNW.t1 pfet_03v3 ad=0.621p pd=3.66u as=0.3588p ps=1.9u w=1.38u l=0.28u
X7 VSS.t3 A.t0 a_492_68# VPW.t5 nfet_03v3 ad=0.26p pd=1.52u as=0.26p ps=1.52u w=1u l=0.28u
X8 a_28_440# A.t2 VDD.t0 VNW.t5 pfet_03v3 ad=0.3588p pd=1.9u as=0.3588p ps=1.9u w=1.38u l=0.28u
X9 a_492_68# B.t0 Y.t5 VPW.t3 nfet_03v3 ad=0.26p pd=1.52u as=0.26p ps=1.52u w=1u l=0.28u
X10 VDD.t1 A.t3 a_28_440# VNW.t4 pfet_03v3 ad=0.3588p pd=1.9u as=0.6072p ps=3.64u w=1.38u l=0.28u
X11 Y.t1 B.t1 a_172_68# VPW.t2 nfet_03v3 ad=0.26p pd=1.52u as=0.26p ps=1.52u w=1u l=0.28u
R0 VSS.n1 VSS.t0 11.1066
R1 VSS.n2 VSS.t2 10.9684
R2 VSS.n1 VSS.n0 6.38659
R3 VSS.n0 VSS.t1 1.6385
R4 VSS.n0 VSS.t3 1.6385
R5 VSS.n2 VSS.n1 0.4805
R6 VSS VSS.n2 0.0485
R7 Y.n3 Y.n0 7.17115
R8 Y.n3 Y.n2 6.3005
R9 Y.n3 Y.n1 5.58533
R10 Y.n2 Y.t0 1.6385
R11 Y.n2 Y.t2 1.6385
R12 Y.n0 Y.t5 1.6385
R13 Y.n0 Y.t1 1.6385
R14 Y.n1 Y.t4 1.31934
R15 Y.n1 Y.t3 1.31934
R16 Y Y.n3 0.0361897
R17 VDD.n2 VDD.n1 5.52659
R18 VDD.n2 VDD.n0 5.28659
R19 VDD.n0 VDD.t3 1.31934
R20 VDD.n0 VDD.t1 1.31934
R21 VDD.n1 VDD.t0 1.31934
R22 VDD.n1 VDD.t2 1.31934
R23 VDD VDD.n2 0.1685
R24 C.n0 C.t3 29.7219
R25 C.n2 C.t2 26.9258
R26 C.n0 C.t1 23.7255
R27 C.n1 C.t0 21.3803
R28 C.n1 C.n0 16.5048
R29 C C.n2 8.02466
R30 C.n2 C.n1 0.134445
R31 B.n0 B.t2 24.5076
R32 B.n1 B.t3 24.5076
R33 B.n0 B.t0 19.5541
R34 B.n1 B.t1 19.5541
R35 B.n2 B.n0 8.11161
R36 B.n2 B.n1 8.11161
R37 B B.n2 4.1355
R38 A.n0 A.t2 28.2735
R39 A.n1 A.t3 27.7521
R40 A.n1 A.t1 22.7985
R41 A.n0 A.t0 22.2771
R42 A.n2 A.n0 9.23449
R43 A.n2 A.n1 8.0005
R44 A A.n2 0.0390714
R45 VNW.t0 VNW.t1 310.079
R46 VNW.t5 VNW.t0 310.079
R47 VNW.t3 VNW.t5 310.079
R48 VNW.t2 VNW.t3 310.079
R49 VNW.t4 VNW.t2 310.079
R50 VNW VNW.t4 259.69
R51 VPW.t0 VPW.t1 1181.82
R52 VPW.t5 VPW.t0 1181.82
R53 VPW.t3 VPW.t5 1181.82
R54 VPW.t2 VPW.t3 1181.82
R55 VPW.t4 VPW.t2 1181.82
R56 VPW VPW.t4 989.774
C0 Y VDD 0.00367f
C1 B A 0.30381f
C2 A Y 0.13654f
C3 A a_172_68# 0.00499f
C4 a_28_440# VNW 0.02952f
C5 Y C 0.17404f
C6 a_28_440# VDD 0.77237f
C7 a_28_440# A 0.61196f
C8 B VSS 0.04008f
C9 Y VSS 0.22105f
C10 A a_492_68# 0
C11 a_28_440# C 0.0623f
C12 a_172_68# VSS 0.01142f
C13 B Y 0.12743f
C14 Y a_172_68# 0.00197f
C15 VNW VDD 0.13847f
C16 VNW A 0.17942f
C17 a_28_440# VSS 0.01544f
C18 VSS a_492_68# 0.00928f
C19 VNW C 0.18461f
C20 A VDD 0.0439f
C21 B a_28_440# 0.02378f
C22 a_28_440# Y 0.07199f
C23 C VDD 0.01838f
C24 Y a_492_68# 0.01051f
C25 A C 0.03628f
C26 VNW VSS 0.00789f
C27 VSS VDD 0.00807f
C28 B VNW 0.1553f
C29 A VSS 0.05845f
C30 VNW Y 0.01697f
C31 VSS C 0.05598f
C32 B VDD 0.03132f
C33 VSS VPW 0.41393f
C34 Y VPW 0.05405f
C35 VDD VPW 0.3333f
C36 C VPW 0.32483f
C37 B VPW 0.30685f
C38 A VPW 0.25244f
C39 VNW VPW 2.08987f
C40 a_28_440# VPW 0.03302f
C41 VNW.t1 VPW 0.18852f
C42 VNW.t0 VPW 0.0882f
C43 VNW.t5 VPW 0.0882f
C44 VNW.t3 VPW 0.0882f
C45 VNW.t2 VPW 0.0882f
C46 VNW.t4 VPW 0.08103f
C47 A.t2 VPW 0.14617f
C48 A.t0 VPW 0.10276f
C49 A.n0 VPW 0.21031f
C50 A.t3 VPW 0.14476f
C51 A.t1 VPW 0.10417f
C52 A.n1 VPW 0.17535f
C53 A.n2 VPW 0.47309f
C54 B.t2 VPW 0.08369f
C55 B.t0 VPW 0.05831f
C56 B.n0 VPW 0.11415f
C57 B.t3 VPW 0.08369f
C58 B.t1 VPW 0.05831f
C59 B.n1 VPW 0.11415f
C60 B.n2 VPW 0.04881f
C61 C.t2 VPW 0.07151f
C62 C.t3 VPW 0.07432f
C63 C.t1 VPW 0.05253f
C64 C.n0 VPW 0.08851f
C65 C.t0 VPW 0.05041f
C66 C.n1 VPW 0.0631f
C67 C.n2 VPW 0.05722f
C68 VDD.t3 VPW 0.03665f
C69 VDD.t1 VPW 0.03665f
C70 VDD.n0 VPW 0.07351f
C71 VDD.t0 VPW 0.03665f
C72 VDD.t2 VPW 0.03665f
C73 VDD.n1 VPW 0.09388f
C74 VDD.n2 VPW 0.63357f
C75 Y.t5 VPW 0.03581f
C76 Y.t1 VPW 0.03581f
C77 Y.n0 VPW 0.08201f
C78 Y.t4 VPW 0.04941f
C79 Y.t3 VPW 0.04941f
C80 Y.n1 VPW 0.10356f
C81 Y.t0 VPW 0.03581f
C82 Y.t2 VPW 0.03581f
C83 Y.n2 VPW 0.07161f
C84 Y.n3 VPW 0.26034f
C85 VSS.t2 VPW 0.03208f
C86 VSS.t1 VPW 0.01103f
C87 VSS.t3 VPW 0.01103f
C88 VSS.n0 VPW 0.02214f
C89 VSS.t0 VPW 0.03457f
C90 VSS.n1 VPW 0.20617f
C91 VSS.n2 VPW 0.1025f
.ends

* NGSPICE file created from gf180mcu_as_sc_mcu7t3v3__aoi21_4.ext - technology: gf180mcuD

.subckt gf180mcu_as_sc_mcu7t3v3__aoi21_4 VDD VNW VPW VSS Y C B A
X0 Y.t7 A.t3 a_812_68# VPW.t0 nfet_03v3 ad=0.26p pd=1.52u as=0.26p ps=1.52u w=1u l=0.28u
X1 a_28_440# C.t6 Y.t1 VNW.t9 pfet_03v3 ad=0.3588p pd=1.9u as=0.3588p ps=1.9u w=1.38u l=0.28u
X2 VDD.t0 B.t7 a_28_440# VNW.t4 pfet_03v3 ad=0.3588p pd=1.9u as=0.3588p ps=1.9u w=1.38u l=0.28u
X3 Y.t5 C.t3 VSS.t5 VPW.t8 nfet_03v3 ad=0.26p pd=1.52u as=0.44p ps=2.88u w=1u l=0.28u
X4 VSS.t4 B.t2 a_812_68# VPW.t5 nfet_03v3 ad=0.26p pd=1.52u as=0.26p ps=1.52u w=1u l=0.28u
X5 a_28_440# A.t5 VDD.t3 VNW.t2 pfet_03v3 ad=0.3588p pd=1.9u as=0.3588p ps=1.9u w=1.38u l=0.28u
X6 VDD.t6 B.t5 a_28_440# VNW.t6 pfet_03v3 ad=0.3588p pd=1.9u as=0.3588p ps=1.9u w=1.38u l=0.28u
X7 a_812_68# B.t3 VSS.t6 VPW.t4 nfet_03v3 ad=0.26p pd=1.52u as=0.26p ps=1.52u w=1u l=0.28u
X8 VDD.t2 A.t4 a_28_440# VNW.t3 pfet_03v3 ad=0.3588p pd=1.9u as=0.3588p ps=1.9u w=1.38u l=0.28u
X9 a_28_440# B.t4 VDD.t1 VNW.t7 pfet_03v3 ad=0.6348p pd=3.68u as=0.3588p ps=1.9u w=1.38u l=0.28u
X10 a_812_68# A.t0 Y.t8 VPW.t3 nfet_03v3 ad=0.26p pd=1.52u as=0.26p ps=1.52u w=1u l=0.28u
X11 Y.t0 C.t5 a_28_440# VNW.t10 pfet_03v3 ad=0.3588p pd=1.9u as=0.3588p ps=1.9u w=1.38u l=0.28u
X12 a_28_440# A.t7 VDD.t7 VNW.t0 pfet_03v3 ad=0.3588p pd=1.9u as=0.3588p ps=1.9u w=1.38u l=0.28u
X13 VSS.t1 C.t0 Y.t2 VPW.t11 nfet_03v3 ad=0.26p pd=1.52u as=0.26p ps=1.52u w=1u l=0.28u
X14 Y.t6 A.t1 a_812_68# VPW.t2 nfet_03v3 ad=0.26p pd=1.52u as=0.26p ps=1.52u w=1u l=0.28u
X15 a_28_440# C.t4 Y.t11 VNW.t11 pfet_03v3 ad=0.3588p pd=1.9u as=0.3588p ps=1.9u w=1.38u l=0.28u
X16 Y.t4 C.t1 VSS.t3 VPW.t10 nfet_03v3 ad=0.26p pd=1.52u as=0.26p ps=1.52u w=1u l=0.28u
X17 VSS.t0 B.t0 a_812_68# VPW.t7 nfet_03v3 ad=0.46p pd=2.92u as=0.26p ps=1.52u w=1u l=0.28u
X18 VDD.t4 A.t6 a_28_440# VNW.t1 pfet_03v3 ad=0.3588p pd=1.9u as=0.3588p ps=1.9u w=1.38u l=0.28u
X19 a_28_440# B.t6 VDD.t5 VNW.t5 pfet_03v3 ad=0.3588p pd=1.9u as=0.3588p ps=1.9u w=1.38u l=0.28u
X20 a_812_68# A.t2 Y.t10 VPW.t1 nfet_03v3 ad=0.26p pd=1.52u as=0.26p ps=1.52u w=1u l=0.28u
X21 Y.t9 C.t7 a_28_440# VNW.t8 pfet_03v3 ad=0.3588p pd=1.9u as=0.6072p ps=3.64u w=1.38u l=0.28u
X22 VSS.t2 C.t2 Y.t3 VPW.t9 nfet_03v3 ad=0.26p pd=1.52u as=0.26p ps=1.52u w=1u l=0.28u
X23 a_812_68# B.t1 VSS.t7 VPW.t6 nfet_03v3 ad=0.26p pd=1.52u as=0.26p ps=1.52u w=1u l=0.28u
R0 VSS.n6 VSS.t5 10.9684
R1 VSS.n3 VSS.n2 6.38659
R2 VSS.n4 VSS.n1 6.38659
R3 VSS.n5 VSS.n0 6.38659
R4 VSS.n3 VSS.t0 5.2398
R5 VSS.n2 VSS.t7 1.6385
R6 VSS.n2 VSS.t4 1.6385
R7 VSS.n1 VSS.t6 1.6385
R8 VSS.n1 VSS.t1 1.6385
R9 VSS.n0 VSS.t3 1.6385
R10 VSS.n0 VSS.t2 1.6385
R11 VSS.n4 VSS.n3 0.7205
R12 VSS.n5 VSS.n4 0.2405
R13 VSS.n6 VSS.n5 0.2405
R14 VSS VSS.n6 0.0485
R15 VDD.n4 VDD.n3 5.52659
R16 VDD.n6 VDD.n0 5.28659
R17 VDD.n5 VDD.n1 5.28659
R18 VDD.n4 VDD.n2 5.28659
R19 VDD.n0 VDD.t7 1.31934
R20 VDD.n0 VDD.t0 1.31934
R21 VDD.n1 VDD.t3 1.31934
R22 VDD.n1 VDD.t4 1.31934
R23 VDD.n2 VDD.t5 1.31934
R24 VDD.n2 VDD.t2 1.31934
R25 VDD.n3 VDD.t1 1.31934
R26 VDD.n3 VDD.t6 1.31934
R27 VDD VDD.n6 0.6485
R28 VDD.n5 VDD.n4 0.2405
R29 VDD.n6 VDD.n5 0.2405
R30 Y.n2 Y.n0 6.92659
R31 Y.n5 Y.n3 6.92659
R32 Y.n2 Y.n1 6.3005
R33 Y.n5 Y.n4 6.3005
R34 Y.n8 Y.n6 5.82659
R35 Y.n8 Y.n7 5.2005
R36 Y.n4 Y.t10 1.6385
R37 Y.n4 Y.t7 1.6385
R38 Y.n3 Y.t8 1.6385
R39 Y.n3 Y.t6 1.6385
R40 Y.n0 Y.t3 1.6385
R41 Y.n0 Y.t5 1.6385
R42 Y.n1 Y.t2 1.6385
R43 Y.n1 Y.t4 1.6385
R44 Y.n6 Y.t1 1.31934
R45 Y.n6 Y.t9 1.31934
R46 Y.n7 Y.t11 1.31934
R47 Y.n7 Y.t0 1.31934
R48 Y.n9 Y.n5 0.792891
R49 Y.n9 Y.n8 0.3305
R50 Y Y.n9 0.0305
R51 Y.n9 Y.n2 0.0122391
R52 A.n0 A.t4 24.3773
R53 A.n1 A.t5 24.3773
R54 A.n3 A.t6 24.3773
R55 A.n2 A.t7 24.3773
R56 A.n0 A.t0 19.5541
R57 A.n1 A.t1 19.5541
R58 A.n3 A.t2 19.5541
R59 A.n2 A.t3 19.5541
R60 A.n1 A.n0 16.0005
R61 A.n3 A.n2 16.0005
R62 A.n4 A.n1 8.0005
R63 A.n4 A.n3 8.0005
R64 A A.n4 1.93091
R65 B.n0 B.t7 27.0318
R66 B.n3 B.t5 24.3773
R67 B.n1 B.t4 24.3773
R68 B.n2 B.t6 24.3773
R69 B.n0 B.t3 22.2824
R70 B.n3 B.t1 19.5541
R71 B.n1 B.t0 19.5541
R72 B.n2 B.t2 19.5541
R73 B.n3 B.n1 16.0005
R74 B.n3 B.n2 16.0005
R75 B.n4 B.n0 9.88949
R76 B.n4 B.n3 2.20392
R77 B B.n4 0.0288562
R78 C.n0 C.t4 24.3773
R79 C.n1 C.t5 24.3773
R80 C.n2 C.t6 24.3773
R81 C.n3 C.t7 24.3773
R82 C.n0 C.t0 19.5541
R83 C.n1 C.t1 19.5541
R84 C.n2 C.t2 19.5541
R85 C.n3 C.t3 19.5541
R86 C.n1 C.n0 16.0005
R87 C.n2 C.n1 16.0005
R88 C.n4 C.n3 15.2005
R89 C C.n4 2.27173
R90 C.n4 C.n2 0.8005
R91 VNW.t6 VNW.t7 310.079
R92 VNW.t5 VNW.t6 310.079
R93 VNW.t3 VNW.t5 310.079
R94 VNW.t2 VNW.t3 310.079
R95 VNW.t1 VNW.t2 310.079
R96 VNW.t0 VNW.t1 310.079
R97 VNW.t4 VNW.t0 310.079
R98 VNW.t11 VNW.t4 310.079
R99 VNW.t10 VNW.t11 310.079
R100 VNW.t9 VNW.t10 310.079
R101 VNW.t8 VNW.t9 310.079
R102 VNW VNW.t8 259.69
R103 VPW.t6 VPW.t7 1181.82
R104 VPW.t5 VPW.t6 1181.82
R105 VPW.t3 VPW.t5 1181.82
R106 VPW.t2 VPW.t3 1181.82
R107 VPW.t1 VPW.t2 1181.82
R108 VPW.t0 VPW.t1 1181.82
R109 VPW.t4 VPW.t0 1181.82
R110 VPW.t11 VPW.t4 1181.82
R111 VPW.t10 VPW.t11 1181.82
R112 VPW.t9 VPW.t10 1181.82
R113 VPW.t8 VPW.t9 1181.82
R114 VPW VPW.t8 989.774
C0 VSS C 0.08779f
C1 VSS a_812_68# 1.05089f
C2 VSS A 0.03806f
C3 VSS VDD 0.0107f
C4 VSS Y 0.27652f
C5 VSS VNW 0.00933f
C6 VSS B 0.08773f
C7 C a_28_440# 0.08039f
C8 A a_28_440# 0.04625f
C9 VDD a_28_440# 1.31894f
C10 a_812_68# C 0
C11 a_812_68# A 0.06117f
C12 a_28_440# Y 0.21171f
C13 VDD C 0.0378f
C14 a_812_68# VDD 0
C15 A VDD 0.06464f
C16 C Y 0.7016f
C17 a_28_440# VNW 0.04727f
C18 a_812_68# Y 0.53259f
C19 A Y 0.3872f
C20 VDD Y 0.00661f
C21 C VNW 0.35139f
C22 B a_28_440# 1.13974f
C23 a_812_68# VNW 0.00258f
C24 A VNW 0.33548f
C25 VDD VNW 0.25407f
C26 B C 0.04209f
C27 B a_812_68# 0.24781f
C28 B A 0.52018f
C29 Y VNW 0.025f
C30 B VDD 0.09033f
C31 B Y 0.17551f
C32 VSS a_28_440# 0.01864f
C33 B VNW 0.36555f
C34 VSS VPW 0.73369f
C35 VDD VPW 0.69301f
C36 Y VPW 0.05934f
C37 A VPW 0.66852f
C38 B VPW 0.44492f
C39 C VPW 0.65421f
C40 VNW VPW 3.65896f
C41 a_812_68# VPW 0.01071f
C42 a_28_440# VPW 0.03223f
C43 VNW.t7 VPW 0.23581f
C44 VNW.t6 VPW 0.09674f
C45 VNW.t5 VPW 0.09674f
C46 VNW.t3 VPW 0.09674f
C47 VNW.t2 VPW 0.09674f
C48 VNW.t1 VPW 0.09674f
C49 VNW.t0 VPW 0.09674f
C50 VNW.t4 VPW 0.09674f
C51 VNW.t11 VPW 0.09674f
C52 VNW.t10 VPW 0.09674f
C53 VNW.t9 VPW 0.09674f
C54 VNW.t8 VPW 0.08888f
C55 C.t6 VPW 0.07496f
C56 C.t2 VPW 0.05237f
C57 C.t5 VPW 0.07496f
C58 C.t1 VPW 0.05237f
C59 C.t4 VPW 0.07496f
C60 C.t0 VPW 0.05237f
C61 C.n0 VPW 0.12364f
C62 C.n1 VPW 0.15074f
C63 C.n2 VPW 0.11113f
C64 C.t7 VPW 0.07496f
C65 C.t3 VPW 0.05237f
C66 C.n3 VPW 0.1424f
C67 C.n4 VPW 0.06148f
C68 B.t7 VPW 0.13389f
C69 B.t3 VPW 0.09662f
C70 B.n0 VPW 0.2475f
C71 B.t1 VPW 0.08778f
C72 B.t5 VPW 0.12564f
C73 B.t4 VPW 0.12564f
C74 B.t0 VPW 0.08778f
C75 B.n1 VPW 0.20725f
C76 B.t6 VPW 0.12564f
C77 B.t2 VPW 0.08778f
C78 B.n2 VPW 0.20725f
C79 B.n3 VPW 0.27448f
C80 B.n4 VPW 0.85162f
C81 A.t5 VPW 0.08143f
C82 A.t1 VPW 0.0569f
C83 A.t4 VPW 0.08143f
C84 A.t0 VPW 0.0569f
C85 A.n0 VPW 0.13433f
C86 A.n1 VPW 0.14112f
C87 A.t6 VPW 0.08143f
C88 A.t2 VPW 0.0569f
C89 A.t7 VPW 0.08143f
C90 A.t3 VPW 0.0569f
C91 A.n2 VPW 0.13433f
C92 A.n3 VPW 0.14112f
C93 A.n4 VPW 0.08425f
C94 Y.t3 VPW 0.05234f
C95 Y.t5 VPW 0.05234f
C96 Y.n0 VPW 0.11401f
C97 Y.t2 VPW 0.05234f
C98 Y.t4 VPW 0.05234f
C99 Y.n1 VPW 0.10468f
C100 Y.n2 VPW 0.16939f
C101 Y.t8 VPW 0.05234f
C102 Y.t6 VPW 0.05234f
C103 Y.n3 VPW 0.11284f
C104 Y.t10 VPW 0.05234f
C105 Y.t7 VPW 0.05234f
C106 Y.n4 VPW 0.10468f
C107 Y.n5 VPW 0.24997f
C108 Y.t1 VPW 0.07223f
C109 Y.t9 VPW 0.07223f
C110 Y.n6 VPW 0.15426f
C111 Y.t11 VPW 0.07223f
C112 Y.t0 VPW 0.07223f
C113 Y.n7 VPW 0.14446f
C114 Y.n8 VPW 0.25534f
C115 Y.n9 VPW 0.19149f
C116 VDD.t7 VPW 0.03329f
C117 VDD.t0 VPW 0.03329f
C118 VDD.n0 VPW 0.06677f
C119 VDD.t3 VPW 0.03329f
C120 VDD.t4 VPW 0.03329f
C121 VDD.n1 VPW 0.06677f
C122 VDD.t5 VPW 0.03329f
C123 VDD.t2 VPW 0.03329f
C124 VDD.n2 VPW 0.06677f
C125 VDD.t1 VPW 0.03329f
C126 VDD.t6 VPW 0.03329f
C127 VDD.n3 VPW 0.0787f
C128 VDD.n4 VPW 0.45738f
C129 VDD.n5 VPW 0.19458f
C130 VDD.n6 VPW 0.34599f
C131 VSS.t5 VPW 0.06319f
C132 VSS.t3 VPW 0.02173f
C133 VSS.t2 VPW 0.02173f
C134 VSS.n0 VPW 0.04361f
C135 VSS.t6 VPW 0.02173f
C136 VSS.t1 VPW 0.02173f
C137 VSS.n1 VPW 0.04361f
C138 VSS.t7 VPW 0.02173f
C139 VSS.t4 VPW 0.02173f
C140 VSS.n2 VPW 0.04361f
C141 VSS.t0 VPW 0.06976f
C142 VSS.n3 VPW 0.53658f
C143 VSS.n4 VPW 0.33583f
C144 VSS.n5 VPW 0.17534f
C145 VSS.n6 VPW 0.12165f
.ends

* NGSPICE file created from gf180mcu_as_sc_mcu7t3v3__aoi21b_2.ext - technology: gf180mcuD

.subckt gf180mcu_as_sc_mcu7t3v3__aoi21b_2 VDD VNW VPW VSS Y C B A
X0 a_364_440# C.t2 Y.t2 VNW.t1 pfet_03v3 ad=0.621p pd=3.66u as=0.3588p ps=1.9u w=1.38u l=0.28u
X1 Y.t4 B.t1 a_508_68# VPW.t4 nfet_03v3 ad=0.26p pd=1.52u as=0.26p ps=1.52u w=1u l=0.28u
X2 VSS.t0 C.t0 Y.t0 VPW.t1 nfet_03v3 ad=0.45p pd=2.9u as=0.26p ps=1.52u w=1u l=0.28u
X3 a_220_68# A.t0 VSS.t4 VPW.t6 nfet_03v3 ad=0.44p pd=2.88u as=0.47p ps=2.94u w=1u l=0.28u
X4 a_508_68# a_220_68# VSS.t2 VPW.t2 nfet_03v3 ad=0.26p pd=1.52u as=0.44p ps=2.88u w=1u l=0.28u
X5 a_220_68# A.t1 VDD.t0 VNW.t6 pfet_03v3 ad=0.6072p pd=3.64u as=0.6348p ps=3.68u w=1.38u l=0.28u
X6 VDD.t1 a_220_68# a_364_440# VNW.t2 pfet_03v3 ad=0.3588p pd=1.9u as=0.6072p ps=3.64u w=1.38u l=0.28u
X7 a_364_440# a_220_68# VDD.t2 VNW.t3 pfet_03v3 ad=0.3588p pd=1.9u as=0.3588p ps=1.9u w=1.38u l=0.28u
X8 Y.t3 C.t1 VSS.t1 VPW.t0 nfet_03v3 ad=0.26p pd=1.52u as=0.26p ps=1.52u w=1u l=0.28u
X9 Y.t1 C.t3 a_364_440# VNW.t0 pfet_03v3 ad=0.3588p pd=1.9u as=0.3588p ps=1.9u w=1.38u l=0.28u
X10 VSS.t3 a_220_68# a_828_68# VPW.t3 nfet_03v3 ad=0.26p pd=1.52u as=0.26p ps=1.52u w=1u l=0.28u
X11 a_364_440# B.t3 VDD.t3 VNW.t4 pfet_03v3 ad=0.3588p pd=1.9u as=0.3588p ps=1.9u w=1.38u l=0.28u
X12 a_828_68# B.t0 Y.t5 VPW.t5 nfet_03v3 ad=0.26p pd=1.52u as=0.26p ps=1.52u w=1u l=0.28u
X13 VDD.t4 B.t2 a_364_440# VNW.t5 pfet_03v3 ad=0.3588p pd=1.9u as=0.3588p ps=1.9u w=1.38u l=0.28u
R0 VSS.n1 VSS.t0 11.1066
R1 VSS.n2 VSS.t2 10.9684
R2 VSS.n3 VSS.t4 10.6759
R3 VSS.n1 VSS.n0 6.38659
R4 VSS.n0 VSS.t1 1.6385
R5 VSS.n0 VSS.t3 1.6385
R6 VSS.n2 VSS.n1 0.4805
R7 VSS.n3 VSS.n2 0.221
R8 VSS VSS.n3 0.08
R9 Y.n3 Y.n0 7.17115
R10 Y.n3 Y.n2 6.3005
R11 Y.n3 Y.n1 5.58533
R12 Y.n2 Y.t0 1.6385
R13 Y.n2 Y.t3 1.6385
R14 Y.n0 Y.t5 1.6385
R15 Y.n0 Y.t4 1.6385
R16 Y.n1 Y.t2 1.31934
R17 Y.n1 Y.t1 1.31934
R18 Y Y.n3 0.0361897
R19 VDD.n2 VDD.n1 5.52659
R20 VDD.n2 VDD.n0 5.28659
R21 VDD.n3 VDD.t0 4.24775
R22 VDD.n0 VDD.t3 1.31934
R23 VDD.n0 VDD.t1 1.31934
R24 VDD.n1 VDD.t2 1.31934
R25 VDD.n1 VDD.t4 1.31934
R26 VDD.n3 VDD.n2 0.3395
R27 VDD VDD.n3 0.0815
R28 C.n0 C.t3 29.7219
R29 C.n2 C.t2 26.9258
R30 C.n0 C.t1 23.7255
R31 C.n1 C.t0 21.3803
R32 C.n1 C.n0 16.5048
R33 C C.n2 8.02466
R34 C.n2 C.n1 0.134445
R35 B.n0 B.t2 24.5076
R36 B.n1 B.t3 24.5076
R37 B.n0 B.t0 19.5541
R38 B.n1 B.t1 19.5541
R39 B.n2 B.n0 8.11161
R40 B.n2 B.n1 8.11161
R41 B B.n2 4.1355
R42 A.n0 A.t1 27.3301
R43 A.n0 A.t0 22.6372
R44 A A.n0 8.06606
R45 VNW.t6 VNW.t2 558.14
R46 VNW VNW.t6 352.714
R47 VNW.t0 VNW.t1 310.079
R48 VNW.t3 VNW.t0 310.079
R49 VNW.t5 VNW.t3 310.079
R50 VNW.t4 VNW.t5 310.079
R51 VNW.t2 VNW.t4 310.079
R52 VPW.t6 VPW.t2 2127.27
R53 VPW VPW.t6 1344.32
R54 VPW.t0 VPW.t1 1181.82
R55 VPW.t3 VPW.t0 1181.82
R56 VPW.t5 VPW.t3 1181.82
R57 VPW.t4 VPW.t5 1181.82
R58 VPW.t2 VPW.t4 1181.82
C0 C VDD 0.01838f
C1 B a_364_440# 0.02378f
C2 VSS VDD 0.01997f
C3 B Y 0.12743f
C4 B a_220_68# 0.30645f
C5 Y a_364_440# 0.07199f
C6 VSS B 0.04008f
C7 a_220_68# a_364_440# 0.68189f
C8 C a_364_440# 0.0623f
C9 Y a_220_68# 0.14607f
C10 C Y 0.17404f
C11 VSS a_364_440# 0.00755f
C12 A a_220_68# 0.21338f
C13 C a_220_68# 0.03655f
C14 VSS Y 0.22105f
C15 VSS a_220_68# 0.11809f
C16 VNW VDD 0.20551f
C17 VSS A 0.0388f
C18 VSS C 0.05598f
C19 a_828_68# Y 0.01051f
C20 a_828_68# a_220_68# 0
C21 a_508_68# Y 0.00197f
C22 a_828_68# VSS 0.00928f
C23 B VNW 0.1553f
C24 a_508_68# a_220_68# 0.00687f
C25 B VDD 0.03132f
C26 a_508_68# VSS 0.01142f
C27 VNW a_364_440# 0.02761f
C28 VNW Y 0.01692f
C29 VDD a_364_440# 0.77319f
C30 VNW a_220_68# 0.22174f
C31 VNW A 0.09871f
C32 C VNW 0.18461f
C33 Y VDD 0.00367f
C34 VDD a_220_68# 0.19404f
C35 VDD A 0.05083f
C36 VSS VNW 0.01027f
C37 VSS VPW 0.52708f
C38 Y VPW 0.04608f
C39 VDD VPW 0.38316f
C40 C VPW 0.32486f
C41 B VPW 0.30732f
C42 A VPW 0.25655f
C43 VNW VPW 2.62589f
C44 a_364_440# VPW 0.01861f
C45 a_220_68# VPW 0.22881f
C46 VNW.t1 VPW 0.19341f
C47 VNW.t0 VPW 0.09048f
C48 VNW.t3 VPW 0.09048f
C49 VNW.t5 VPW 0.09048f
C50 VNW.t4 VPW 0.09048f
C51 VNW.t2 VPW 0.12667f
C52 VNW.t6 VPW 0.1329f
C53 A.t1 VPW 0.09652f
C54 A.t0 VPW 0.06977f
C55 A.n0 VPW 0.12418f
C56 B.t2 VPW 0.08401f
C57 B.t0 VPW 0.05854f
C58 B.n0 VPW 0.11459f
C59 B.t3 VPW 0.08401f
C60 B.t1 VPW 0.05854f
C61 B.n1 VPW 0.11459f
C62 B.n2 VPW 0.049f
C63 C.t2 VPW 0.07154f
C64 C.t3 VPW 0.07436f
C65 C.t1 VPW 0.05255f
C66 C.n0 VPW 0.08856f
C67 C.t0 VPW 0.05043f
C68 C.n1 VPW 0.06313f
C69 C.n2 VPW 0.05725f
C70 VDD.t0 VPW 0.09383f
C71 VDD.t3 VPW 0.03386f
C72 VDD.t1 VPW 0.03386f
C73 VDD.n0 VPW 0.06792f
C74 VDD.t2 VPW 0.03386f
C75 VDD.t4 VPW 0.03386f
C76 VDD.n1 VPW 0.08674f
C77 VDD.n2 VPW 0.64992f
C78 VDD.n3 VPW 0.23248f
C79 Y.t5 VPW 0.03625f
C80 Y.t4 VPW 0.03625f
C81 Y.n0 VPW 0.08303f
C82 Y.t2 VPW 0.05003f
C83 Y.t1 VPW 0.05003f
C84 Y.n1 VPW 0.10484f
C85 Y.t0 VPW 0.03625f
C86 Y.t3 VPW 0.03625f
C87 Y.n2 VPW 0.0725f
C88 Y.n3 VPW 0.26357f
C89 VSS.t4 VPW 0.03275f
C90 VSS.t2 VPW 0.03047f
C91 VSS.t1 VPW 0.01048f
C92 VSS.t3 VPW 0.01048f
C93 VSS.n0 VPW 0.02103f
C94 VSS.t0 VPW 0.03283f
C95 VSS.n1 VPW 0.19579f
C96 VSS.n2 VPW 0.12514f
C97 VSS.n3 VPW 0.06072f
.ends

* NGSPICE file created from gf180mcu_as_sc_mcu7t3v3__aoi21b_4.ext - technology: gf180mcuD

.subckt gf180mcu_as_sc_mcu7t3v3__aoi21b_4 VDD VNW VPW VSS Y C A B
X0 VSS.t5 A.t0 a_713_318# VPW.t4 nfet_03v3 ad=0.44p pd=2.88u as=0.44p ps=2.88u w=1u l=0.28u
X1 Y.t4 B.t3 a_812_68# VPW.t5 nfet_03v3 ad=0.26p pd=1.52u as=0.26p ps=1.52u w=1u l=0.28u
X2 a_28_440# C.t6 Y.t10 VNW.t10 pfet_03v3 ad=0.3588p pd=1.9u as=0.3588p ps=1.9u w=1.38u l=0.28u
X3 VDD.t0 a_713_318# a_28_440# VNW.t0 pfet_03v3 ad=0.3588p pd=1.9u as=0.3588p ps=1.9u w=1.38u l=0.28u
X4 Y.t1 C.t3 VSS.t4 VPW.t9 nfet_03v3 ad=0.26p pd=1.52u as=0.44p ps=2.88u w=1u l=0.28u
X5 VSS.t1 a_713_318# a_812_68# VPW.t1 nfet_03v3 ad=0.26p pd=1.52u as=0.26p ps=1.52u w=1u l=0.28u
X6 a_28_440# B.t5 VDD.t7 VNW.t7 pfet_03v3 ad=0.3588p pd=1.9u as=0.3588p ps=1.9u w=1.38u l=0.28u
X7 VDD.t2 a_713_318# a_28_440# VNW.t2 pfet_03v3 ad=0.3588p pd=1.9u as=0.3588p ps=1.9u w=1.38u l=0.28u
X8 a_812_68# a_713_318# VSS.t0 VPW.t0 nfet_03v3 ad=0.26p pd=1.52u as=0.26p ps=1.52u w=1u l=0.28u
X9 VDD.t6 B.t4 a_28_440# VNW.t8 pfet_03v3 ad=0.3588p pd=1.9u as=0.3588p ps=1.9u w=1.38u l=0.28u
X10 a_28_440# a_713_318# VDD.t3 VNW.t3 pfet_03v3 ad=0.6348p pd=3.68u as=0.3588p ps=1.9u w=1.38u l=0.28u
X11 a_812_68# B.t0 Y.t8 VPW.t8 nfet_03v3 ad=0.26p pd=1.52u as=0.26p ps=1.52u w=1u l=0.28u
X12 Y.t6 C.t5 a_28_440# VNW.t11 pfet_03v3 ad=0.3588p pd=1.9u as=0.3588p ps=1.9u w=1.38u l=0.28u
X13 a_28_440# B.t7 VDD.t8 VNW.t5 pfet_03v3 ad=0.3588p pd=1.9u as=0.3588p ps=1.9u w=1.38u l=0.28u
X14 VSS.t6 C.t0 Y.t5 VPW.t12 nfet_03v3 ad=0.26p pd=1.52u as=0.26p ps=1.52u w=1u l=0.28u
X15 Y.t2 B.t1 a_812_68# VPW.t7 nfet_03v3 ad=0.26p pd=1.52u as=0.26p ps=1.52u w=1u l=0.28u
X16 a_28_440# C.t4 Y.t3 VNW.t12 pfet_03v3 ad=0.3588p pd=1.9u as=0.3588p ps=1.9u w=1.38u l=0.28u
X17 Y.t9 C.t1 VSS.t7 VPW.t11 nfet_03v3 ad=0.26p pd=1.52u as=0.26p ps=1.52u w=1u l=0.28u
X18 VSS.t3 a_713_318# a_812_68# VPW.t3 nfet_03v3 ad=0.46p pd=2.92u as=0.26p ps=1.52u w=1u l=0.28u
X19 VDD.t4 B.t6 a_28_440# VNW.t6 pfet_03v3 ad=0.3588p pd=1.9u as=0.3588p ps=1.9u w=1.38u l=0.28u
X20 a_28_440# a_713_318# VDD.t1 VNW.t1 pfet_03v3 ad=0.3588p pd=1.9u as=0.3588p ps=1.9u w=1.38u l=0.28u
X21 a_812_68# B.t2 Y.t0 VPW.t6 nfet_03v3 ad=0.26p pd=1.52u as=0.26p ps=1.52u w=1u l=0.28u
X22 VDD.t5 A.t1 a_713_318# VNW.t4 pfet_03v3 ad=0.6072p pd=3.64u as=0.6072p ps=3.64u w=1.38u l=0.28u
X23 Y.t7 C.t7 a_28_440# VNW.t9 pfet_03v3 ad=0.3588p pd=1.9u as=0.6072p ps=3.64u w=1.38u l=0.28u
X24 VSS.t8 C.t2 Y.t11 VPW.t10 nfet_03v3 ad=0.26p pd=1.52u as=0.26p ps=1.52u w=1u l=0.28u
X25 a_812_68# a_713_318# VSS.t2 VPW.t2 nfet_03v3 ad=0.26p pd=1.52u as=0.26p ps=1.52u w=1u l=0.28u
R0 VSS.n7 VSS.t4 10.9684
R1 VSS.n4 VSS.n2 6.38659
R2 VSS.n5 VSS.n1 6.38659
R3 VSS.n6 VSS.n0 6.38659
R4 VSS.n3 VSS.t5 5.2188
R5 VSS.n3 VSS.t3 4.9998
R6 VSS.n2 VSS.t2 1.6385
R7 VSS.n2 VSS.t1 1.6385
R8 VSS.n1 VSS.t0 1.6385
R9 VSS.n1 VSS.t6 1.6385
R10 VSS.n0 VSS.t7 1.6385
R11 VSS.n0 VSS.t8 1.6385
R12 VSS.n5 VSS.n4 0.7205
R13 VSS.n4 VSS.n3 0.2405
R14 VSS.n6 VSS.n5 0.2405
R15 VSS.n7 VSS.n6 0.2405
R16 VSS VSS.n7 0.0485
R17 VDD.n7 VDD.n0 5.28659
R18 VDD.n6 VDD.n1 5.28659
R19 VDD.n5 VDD.n2 5.28659
R20 VDD.n4 VDD.n3 5.28659
R21 VDD.n4 VDD.t5 3.67341
R22 VDD.n0 VDD.t8 1.31934
R23 VDD.n0 VDD.t0 1.31934
R24 VDD.n1 VDD.t7 1.31934
R25 VDD.n1 VDD.t4 1.31934
R26 VDD.n2 VDD.t1 1.31934
R27 VDD.n2 VDD.t6 1.31934
R28 VDD.n3 VDD.t3 1.31934
R29 VDD.n3 VDD.t2 1.31934
R30 VDD VDD.n7 0.6485
R31 VDD.n5 VDD.n4 0.2405
R32 VDD.n6 VDD.n5 0.2405
R33 VDD.n7 VDD.n6 0.2405
R34 Y.n2 Y.n0 6.92659
R35 Y.n5 Y.n3 6.92659
R36 Y.n2 Y.n1 6.3005
R37 Y.n5 Y.n4 6.3005
R38 Y.n8 Y.n6 5.82659
R39 Y.n8 Y.n7 5.2005
R40 Y.n4 Y.t0 1.6385
R41 Y.n4 Y.t4 1.6385
R42 Y.n3 Y.t8 1.6385
R43 Y.n3 Y.t2 1.6385
R44 Y.n0 Y.t11 1.6385
R45 Y.n0 Y.t1 1.6385
R46 Y.n1 Y.t5 1.6385
R47 Y.n1 Y.t9 1.6385
R48 Y.n6 Y.t10 1.31934
R49 Y.n6 Y.t7 1.31934
R50 Y.n7 Y.t3 1.31934
R51 Y.n7 Y.t6 1.31934
R52 Y.n9 Y.n5 0.792891
R53 Y.n9 Y.n8 0.3305
R54 Y Y.n9 0.0305
R55 Y.n9 Y.n2 0.0122391
R56 A.n0 A.t1 26.8449
R57 A.n0 A.t0 22.4693
R58 A A.n0 8.05105
R59 B.n0 B.t4 24.3773
R60 B.n1 B.t5 24.3773
R61 B.n3 B.t6 24.3773
R62 B.n2 B.t7 24.3773
R63 B.n0 B.t0 19.5541
R64 B.n1 B.t1 19.5541
R65 B.n3 B.t2 19.5541
R66 B.n2 B.t3 19.5541
R67 B.n1 B.n0 16.0005
R68 B.n3 B.n2 16.0005
R69 B.n4 B.n1 8.0005
R70 B.n4 B.n3 8.0005
R71 B B.n4 1.93091
R72 C.n0 C.t4 24.3773
R73 C.n1 C.t5 24.3773
R74 C.n2 C.t6 24.3773
R75 C.n3 C.t7 24.3773
R76 C.n0 C.t0 19.5541
R77 C.n1 C.t1 19.5541
R78 C.n2 C.t2 19.5541
R79 C.n3 C.t3 19.5541
R80 C.n1 C.n0 16.0005
R81 C.n2 C.n1 16.0005
R82 C.n4 C.n3 15.2005
R83 C C.n4 2.27173
R84 C.n4 C.n2 0.8005
R85 VNW.t3 VNW.t4 565.891
R86 VNW.t2 VNW.t3 310.079
R87 VNW.t1 VNW.t2 310.079
R88 VNW.t8 VNW.t1 310.079
R89 VNW.t7 VNW.t8 310.079
R90 VNW.t6 VNW.t7 310.079
R91 VNW.t5 VNW.t6 310.079
R92 VNW.t0 VNW.t5 310.079
R93 VNW.t12 VNW.t0 310.079
R94 VNW.t11 VNW.t12 310.079
R95 VNW.t10 VNW.t11 310.079
R96 VNW.t9 VNW.t10 310.079
R97 VNW VNW.t9 259.69
R98 VPW.t3 VPW.t4 2156.82
R99 VPW.t2 VPW.t3 1181.82
R100 VPW.t1 VPW.t2 1181.82
R101 VPW.t8 VPW.t1 1181.82
R102 VPW.t7 VPW.t8 1181.82
R103 VPW.t6 VPW.t7 1181.82
R104 VPW.t5 VPW.t6 1181.82
R105 VPW.t0 VPW.t5 1181.82
R106 VPW.t12 VPW.t0 1181.82
R107 VPW.t11 VPW.t12 1181.82
R108 VPW.t10 VPW.t11 1181.82
R109 VPW.t9 VPW.t10 1181.82
R110 VPW VPW.t9 989.774
C0 a_812_68# C 0
C1 a_812_68# VDD 0
C2 B a_812_68# 0.06117f
C3 A VDD 0.05243f
C4 C a_28_440# 0.08039f
C5 VDD a_28_440# 1.31981f
C6 B a_28_440# 0.04625f
C7 VDD C 0.0378f
C8 a_812_68# Y 0.53259f
C9 B VDD 0.06464f
C10 VSS a_812_68# 1.05089f
C11 a_812_68# VNW 0.00258f
C12 VSS A 0.05679f
C13 A VNW 0.09517f
C14 a_28_440# Y 0.21171f
C15 a_812_68# a_713_318# 0.24781f
C16 A a_713_318# 0.11131f
C17 C Y 0.7016f
C18 VSS a_28_440# 0.00566f
C19 a_28_440# VNW 0.04241f
C20 VDD Y 0.00661f
C21 VSS C 0.08779f
C22 C VNW 0.35139f
C23 B Y 0.3872f
C24 a_28_440# a_713_318# 1.22804f
C25 VSS VDD 0.01784f
C26 VDD VNW 0.30134f
C27 VSS B 0.03806f
C28 B VNW 0.33548f
C29 C a_713_318# 0.04214f
C30 VDD a_713_318# 0.2632f
C31 B a_713_318# 0.52093f
C32 VSS Y 0.27652f
C33 Y VNW 0.025f
C34 VSS VNW 0.0058f
C35 Y a_713_318# 0.17681f
C36 VSS a_713_318# 0.25146f
C37 VNW a_713_318# 0.41072f
C38 VSS VPW 0.80534f
C39 VDD VPW 0.76733f
C40 Y VPW 0.05808f
C41 A VPW 0.18281f
C42 B VPW 0.66865f
C43 C VPW 0.65421f
C44 VNW VPW 4.00853f
C45 a_812_68# VPW 0.01071f
C46 a_28_440# VPW 0.01705f
C47 a_713_318# VPW 0.43895f
C48 VNW.t4 VPW 0.24133f
C49 VNW.t3 VPW 0.14057f
C50 VNW.t2 VPW 0.09952f
C51 VNW.t1 VPW 0.09952f
C52 VNW.t8 VPW 0.09952f
C53 VNW.t7 VPW 0.09952f
C54 VNW.t6 VPW 0.09952f
C55 VNW.t5 VPW 0.09952f
C56 VNW.t0 VPW 0.09952f
C57 VNW.t12 VPW 0.09952f
C58 VNW.t11 VPW 0.09952f
C59 VNW.t10 VPW 0.09952f
C60 VNW.t9 VPW 0.09143f
C61 C.t6 VPW 0.07496f
C62 C.t2 VPW 0.05237f
C63 C.t5 VPW 0.07496f
C64 C.t1 VPW 0.05237f
C65 C.t4 VPW 0.07496f
C66 C.t0 VPW 0.05237f
C67 C.n0 VPW 0.12365f
C68 C.n1 VPW 0.15075f
C69 C.n2 VPW 0.11114f
C70 C.t7 VPW 0.07496f
C71 C.t3 VPW 0.05237f
C72 C.n3 VPW 0.14241f
C73 C.n4 VPW 0.06148f
C74 B.t5 VPW 0.08148f
C75 B.t1 VPW 0.05693f
C76 B.t4 VPW 0.08148f
C77 B.t0 VPW 0.05693f
C78 B.n0 VPW 0.1344f
C79 B.n1 VPW 0.14119f
C80 B.t6 VPW 0.08148f
C81 B.t2 VPW 0.05693f
C82 B.t7 VPW 0.08148f
C83 B.t3 VPW 0.05693f
C84 B.n2 VPW 0.1344f
C85 B.n3 VPW 0.14119f
C86 B.n4 VPW 0.08429f
C87 A.t1 VPW 0.08731f
C88 A.t0 VPW 0.06344f
C89 A.n0 VPW 0.11946f
C90 Y.t11 VPW 0.05237f
C91 Y.t1 VPW 0.05237f
C92 Y.n0 VPW 0.11408f
C93 Y.t5 VPW 0.05237f
C94 Y.t9 VPW 0.05237f
C95 Y.n1 VPW 0.10474f
C96 Y.n2 VPW 0.16948f
C97 Y.t8 VPW 0.05237f
C98 Y.t2 VPW 0.05237f
C99 Y.n3 VPW 0.11291f
C100 Y.t0 VPW 0.05237f
C101 Y.t4 VPW 0.05237f
C102 Y.n4 VPW 0.10474f
C103 Y.n5 VPW 0.25011f
C104 Y.t10 VPW 0.07227f
C105 Y.t7 VPW 0.07227f
C106 Y.n6 VPW 0.15435f
C107 Y.t3 VPW 0.07227f
C108 Y.t6 VPW 0.07227f
C109 Y.n7 VPW 0.14454f
C110 Y.n8 VPW 0.25549f
C111 Y.n9 VPW 0.1916f
C112 VDD.t8 VPW 0.03303f
C113 VDD.t0 VPW 0.03303f
C114 VDD.n0 VPW 0.06626f
C115 VDD.t7 VPW 0.03303f
C116 VDD.t4 VPW 0.03303f
C117 VDD.n1 VPW 0.06626f
C118 VDD.t1 VPW 0.03303f
C119 VDD.t6 VPW 0.03303f
C120 VDD.n2 VPW 0.06626f
C121 VDD.t3 VPW 0.03303f
C122 VDD.t2 VPW 0.03303f
C123 VDD.n3 VPW 0.06626f
C124 VDD.t5 VPW 0.10766f
C125 VDD.n4 VPW 0.45918f
C126 VDD.n5 VPW 0.19309f
C127 VDD.n6 VPW 0.19309f
C128 VDD.n7 VPW 0.34335f
C129 VSS.t4 VPW 0.06264f
C130 VSS.t7 VPW 0.02154f
C131 VSS.t8 VPW 0.02154f
C132 VSS.n0 VPW 0.04323f
C133 VSS.t0 VPW 0.02154f
C134 VSS.t6 VPW 0.02154f
C135 VSS.n1 VPW 0.04323f
C136 VSS.t2 VPW 0.02154f
C137 VSS.t1 VPW 0.02154f
C138 VSS.n2 VPW 0.04323f
C139 VSS.t3 VPW 0.0596f
C140 VSS.t5 VPW 0.06436f
C141 VSS.n3 VPW 0.36922f
C142 VSS.n4 VPW 0.33288f
C143 VSS.n5 VPW 0.33288f
C144 VSS.n6 VPW 0.1738f
C145 VSS.n7 VPW 0.12059f
.ends

* NGSPICE file created from gf180mcu_as_sc_mcu7t3v3__aoi22_2.ext - technology: gf180mcuD

.subckt gf180mcu_as_sc_mcu7t3v3__aoi22_2 VDD VNW VPW VSS Y A B C D
X0 a_172_440# D.t2 VDD.t1 VNW.t1 pfet_03v3 ad=0.7797p pd=3.89u as=0.3588p ps=1.9u w=1.38u l=0.28u
X1 Y.t3 A.t2 a_172_440# VNW.t7 pfet_03v3 ad=0.3588p pd=1.9u as=0.3588p ps=1.9u w=1.38u l=0.28u
X2 VSS.t3 A.t1 a_28_68# VPW.t6 nfet_03v3 ad=0.26p pd=1.52u as=0.44p ps=2.88u w=1u l=0.28u
X3 a_803_68# D.t0 VSS.t2 VPW.t1 nfet_03v3 ad=0.565p pd=3.13u as=0.26p ps=1.52u w=1u l=0.28u
X4 a_172_440# C.t2 VDD.t3 VNW.t3 pfet_03v3 ad=0.3588p pd=1.9u as=0.3588p ps=1.9u w=1.38u l=0.28u
X5 VSS.t1 D.t1 a_803_68# VPW.t0 nfet_03v3 ad=0.26p pd=1.52u as=0.26p ps=1.52u w=1u l=0.28u
X6 a_172_440# B.t3 Y.t1 VNW.t4 pfet_03v3 ad=0.3588p pd=1.9u as=0.3588p ps=1.9u w=1.38u l=0.28u
X7 a_28_68# B.t0 Y.t6 VPW.t5 nfet_03v3 ad=0.44p pd=2.88u as=0.26p ps=1.52u w=1u l=0.28u
X8 a_803_68# C.t0 Y.t7 VPW.t3 nfet_03v3 ad=0.26p pd=1.52u as=0.26p ps=1.52u w=1u l=0.28u
X9 Y.t5 B.t2 a_172_440# VNW.t5 pfet_03v3 ad=0.6072p pd=3.64u as=0.3588p ps=1.9u w=1.38u l=0.28u
X10 Y.t2 B.t1 a_28_68# VPW.t4 nfet_03v3 ad=0.26p pd=1.52u as=0.26p ps=1.52u w=1u l=0.28u
X11 VDD.t2 D.t3 a_172_440# VNW.t0 pfet_03v3 ad=0.3588p pd=1.9u as=0.3588p ps=1.9u w=1.38u l=0.28u
X12 VDD.t0 C.t3 a_172_440# VNW.t2 pfet_03v3 ad=0.3588p pd=1.9u as=0.6072p ps=3.64u w=1.38u l=0.28u
X13 a_172_440# A.t3 Y.t0 VNW.t6 pfet_03v3 ad=0.3588p pd=1.9u as=0.6072p ps=3.64u w=1.38u l=0.28u
X14 a_28_68# A.t0 VSS.t0 VPW.t7 nfet_03v3 ad=0.26p pd=1.52u as=0.26p ps=1.52u w=1u l=0.28u
X15 Y.t4 C.t1 a_803_68# VPW.t2 nfet_03v3 ad=0.26p pd=1.52u as=0.44p ps=2.88u w=1u l=0.28u
R0 VSS.n2 VSS.n1 7.20784
R1 VSS.n2 VSS.n0 6.38659
R2 VSS.n1 VSS.t2 1.6385
R3 VSS.n1 VSS.t1 1.6385
R4 VSS.n0 VSS.t0 1.6385
R5 VSS.n0 VSS.t3 1.6385
R6 VSS VSS.n2 0.1685
R7 VDD.n2 VDD.n1 5.52659
R8 VDD.n2 VDD.n0 5.28659
R9 VDD.n0 VDD.t3 1.31934
R10 VDD.n0 VDD.t0 1.31934
R11 VDD.n1 VDD.t1 1.31934
R12 VDD.n1 VDD.t2 1.31934
R13 VDD VDD.n2 0.74975
R14 Y.n3 Y.t0 7.11706
R15 Y.n5 Y.n1 6.71724
R16 Y.n5 Y.n0 6.6018
R17 Y.n4 Y.t5 6.51934
R18 Y.n3 Y.n2 5.2005
R19 Y.n1 Y.t7 1.6385
R20 Y.n1 Y.t4 1.6385
R21 Y.n0 Y.t6 1.6385
R22 Y.n0 Y.t2 1.6385
R23 Y.n2 Y.t1 1.31934
R24 Y.n2 Y.t3 1.31934
R25 Y.n4 Y.n3 0.581789
R26 Y.n5 Y.n4 0.357596
R27 Y Y.n5 0.0240227
R28 D.n0 D.t2 24.1166
R29 D.n1 D.t3 24.1166
R30 D.n0 D.t0 19.5541
R31 D.n1 D.t1 19.5541
R32 D.n2 D.n0 7.78717
R33 D.n2 D.n1 7.78717
R34 D D.n2 4.1301
R35 C.n0 C.t2 24.1166
R36 C.n1 C.t3 24.1166
R37 C.n0 C.t0 19.5541
R38 C.n1 C.t1 19.5541
R39 C.n2 C.n0 7.78717
R40 C.n2 C.n1 7.78717
R41 C C.n2 4.1301
R42 B.n0 B.t2 24.1166
R43 B.n1 B.t3 24.1166
R44 B.n0 B.t0 19.5541
R45 B.n1 B.t1 19.5541
R46 B.n2 B.n0 7.78717
R47 B.n2 B.n1 7.78717
R48 B B.n2 4.1301
R49 A.n0 A.t2 24.1166
R50 A.n1 A.t3 24.1166
R51 A.n0 A.t0 19.5541
R52 A.n1 A.t1 19.5541
R53 A.n2 A.n0 7.78717
R54 A.n2 A.n1 7.78717
R55 A A.n2 4.1301
R56 VNW.t5 VNW.t2 571.706
R57 VNW.t0 VNW.t1 310.079
R58 VNW.t3 VNW.t0 310.079
R59 VNW.t2 VNW.t3 310.079
R60 VNW.t4 VNW.t5 310.079
R61 VNW.t7 VNW.t4 310.079
R62 VNW.t6 VNW.t7 310.079
R63 VNW VNW.t6 259.69
R64 VPW.t5 VPW.t2 2178.98
R65 VPW.t0 VPW.t1 1181.82
R66 VPW.t3 VPW.t0 1181.82
R67 VPW.t2 VPW.t3 1181.82
R68 VPW.t4 VPW.t5 1181.82
R69 VPW.t7 VPW.t4 1181.82
R70 VPW.t6 VPW.t7 1181.82
R71 VPW VPW.t6 989.774
C0 Y C 0.15382f
C1 VDD C 0.0363f
C2 a_172_440# Y 0.54269f
C3 a_172_440# VDD 1.01923f
C4 Y a_803_68# 0.3033f
C5 VDD a_803_68# 0.00158f
C6 VSS D 0.03134f
C7 Y a_28_68# 0.32294f
C8 Y VNW 0.04618f
C9 VDD a_28_68# 0
C10 Y A 0.13865f
C11 VNW VDD 0.17947f
C12 VDD A 0.02138f
C13 C D 0.06302f
C14 B VSS 0.01908f
C15 B C 0.0126f
C16 a_172_440# D 0.11525f
C17 B a_172_440# 0.02108f
C18 VSS C 0.01952f
C19 D a_803_68# 0.1747f
C20 Y VDD 0.0475f
C21 a_28_68# D 0
C22 VNW D 0.16492f
C23 a_172_440# VSS 0
C24 B a_803_68# 0
C25 a_172_440# C 0.11957f
C26 B a_28_68# 0.0389f
C27 B VNW 0.16307f
C28 B A 0.06188f
C29 VSS a_803_68# 0.54501f
C30 VSS a_28_68# 0.63234f
C31 VSS VNW 0.00337f
C32 VSS A 0.03113f
C33 C a_803_68# 0.04215f
C34 C a_28_68# 0
C35 VNW C 0.16387f
C36 Y D 0.00189f
C37 a_172_440# a_803_68# 0.03381f
C38 VDD D 0.03577f
C39 a_172_440# VNW 0.04141f
C40 a_172_440# A 0.0139f
C41 B Y 0.31243f
C42 B VDD 0.01797f
C43 a_28_68# a_803_68# 0.03575f
C44 VNW a_803_68# 0.00568f
C45 VSS Y 0.02692f
C46 VSS VDD 0.00595f
C47 VNW a_28_68# 0.00457f
C48 A a_28_68# 0.17261f
C49 VNW A 0.16378f
C50 VSS VPW 0.58889f
C51 VDD VPW 0.67038f
C52 Y VPW 0.07754f
C53 D VPW 0.32805f
C54 C VPW 0.30641f
C55 B VPW 0.31226f
C56 A VPW 0.33052f
C57 VNW VPW 2.78123f
C58 a_803_68# VPW 0.02524f
C59 a_28_68# VPW 0.03675f
C60 a_172_440# VPW 0.02796f
C61 VNW.t1 VPW 0.18027f
C62 VNW.t0 VPW 0.0861f
C63 VNW.t3 VPW 0.0861f
C64 VNW.t2 VPW 0.12242f
C65 VNW.t5 VPW 0.12242f
C66 VNW.t4 VPW 0.0861f
C67 VNW.t7 VPW 0.0861f
C68 VNW.t6 VPW 0.0791f
C69 A.t2 VPW 0.07291f
C70 A.t0 VPW 0.05122f
C71 A.n0 VPW 0.10109f
C72 A.t3 VPW 0.07291f
C73 A.t1 VPW 0.05122f
C74 A.n1 VPW 0.10109f
C75 A.n2 VPW 0.04448f
C76 B.t2 VPW 0.07799f
C77 B.t0 VPW 0.05478f
C78 B.n0 VPW 0.10812f
C79 B.t3 VPW 0.07799f
C80 B.t1 VPW 0.05478f
C81 B.n1 VPW 0.10812f
C82 B.n2 VPW 0.04765f
C83 C.t2 VPW 0.07363f
C84 C.t0 VPW 0.05172f
C85 C.n0 VPW 0.10209f
C86 C.t3 VPW 0.07363f
C87 C.t1 VPW 0.05172f
C88 C.n1 VPW 0.10209f
C89 C.n2 VPW 0.04499f
C90 D.t2 VPW 0.07068f
C91 D.t0 VPW 0.04965f
C92 D.n0 VPW 0.098f
C93 D.t3 VPW 0.07068f
C94 D.t1 VPW 0.04965f
C95 D.n1 VPW 0.098f
C96 D.n2 VPW 0.04319f
C97 Y.t6 VPW 0.04927f
C98 Y.t2 VPW 0.04927f
C99 Y.n0 VPW 0.10107f
C100 Y.t7 VPW 0.04927f
C101 Y.t4 VPW 0.04927f
C102 Y.n1 VPW 0.10248f
C103 Y.t0 VPW 0.20535f
C104 Y.t1 VPW 0.06799f
C105 Y.t3 VPW 0.06799f
C106 Y.n2 VPW 0.13599f
C107 Y.n3 VPW 0.25659f
C108 Y.t5 VPW 0.19733f
C109 Y.n4 VPW 0.21664f
C110 Y.n5 VPW 0.33824f
C111 VDD.t3 VPW 0.03877f
C112 VDD.t0 VPW 0.03877f
C113 VDD.n0 VPW 0.07776f
C114 VDD.t1 VPW 0.03877f
C115 VDD.t2 VPW 0.03877f
C116 VDD.n1 VPW 0.09011f
C117 VDD.n2 VPW 0.71867f
C118 VSS.t0 VPW 0.02887f
C119 VSS.t3 VPW 0.02887f
C120 VSS.n0 VPW 0.05794f
C121 VSS.t2 VPW 0.02887f
C122 VSS.t1 VPW 0.02887f
C123 VSS.n1 VPW 0.12066f
C124 VSS.n2 VPW 0.94687f
.ends

* NGSPICE file created from gf180mcu_as_sc_mcu7t3v3__aoi22_4.ext - technology: gf180mcuD

.subckt gf180mcu_as_sc_mcu7t3v3__aoi22_4 VDD VNW VPW VSS Y A B C D
X0 a_28_440# C.t4 VDD.t2 VNW.t7 pfet_03v3 ad=0.3588p pd=1.9u as=0.3588p ps=1.9u w=1.38u l=0.28u
X1 a_28_68# B.t2 Y.t15 VPW.t9 nfet_03v3 ad=0.26p pd=1.52u as=0.26p ps=1.52u w=1u l=0.28u
X2 a_28_440# A.t6 Y.t4 VNW.t13 pfet_03v3 ad=0.3588p pd=1.9u as=0.3588p ps=1.9u w=1.38u l=0.28u
X3 Y.t9 B.t7 a_28_440# VNW.t8 pfet_03v3 ad=0.3588p pd=1.9u as=0.3588p ps=1.9u w=1.38u l=0.28u
X4 VDD.t1 D.t7 a_28_440# VNW.t0 pfet_03v3 ad=0.3588p pd=1.9u as=0.3588p ps=1.9u w=1.38u l=0.28u
X5 VSS.t0 A.t3 a_28_68# VPW.t12 nfet_03v3 ad=0.26p pd=1.52u as=0.44p ps=2.88u w=1u l=0.28u
X6 VSS.t2 D.t3 a_1436_68# VPW.t0 nfet_03v3 ad=0.26p pd=1.52u as=0.26p ps=1.52u w=1u l=0.28u
X7 a_28_440# D.t4 VDD.t3 VNW.t3 pfet_03v3 ad=0.6072p pd=3.64u as=0.3588p ps=1.9u w=1.38u l=0.28u
X8 a_28_440# B.t4 Y.t3 VNW.t11 pfet_03v3 ad=0.8004p pd=2.54u as=0.3588p ps=1.9u w=1.38u l=0.28u
X9 VDD.t6 C.t7 a_28_440# VNW.t4 pfet_03v3 ad=0.3588p pd=1.9u as=0.8004p ps=2.54u w=1.38u l=0.28u
X10 Y.t5 C.t1 a_1436_68# VPW.t6 nfet_03v3 ad=0.26p pd=1.52u as=0.26p ps=1.52u w=1u l=0.28u
X11 Y.t1 B.t3 a_28_68# VPW.t8 nfet_03v3 ad=0.26p pd=1.52u as=0.26p ps=1.52u w=1u l=0.28u
X12 a_1436_68# C.t0 Y.t8 VPW.t7 nfet_03v3 ad=0.26p pd=1.52u as=0.26p ps=1.52u w=1u l=0.28u
X13 a_28_440# C.t6 VDD.t5 VNW.t5 pfet_03v3 ad=0.3588p pd=1.9u as=0.3588p ps=1.9u w=1.38u l=0.28u
X14 Y.t11 A.t5 a_28_440# VNW.t14 pfet_03v3 ad=0.3588p pd=1.9u as=0.3588p ps=1.9u w=1.38u l=0.28u
X15 a_1436_68# C.t2 Y.t13 VPW.t5 nfet_03v3 ad=0.26p pd=1.52u as=0.26p ps=1.52u w=1u l=0.28u
X16 a_1436_68# D.t0 VSS.t7 VPW.t3 nfet_03v3 ad=0.44p pd=2.88u as=0.26p ps=1.52u w=1u l=0.28u
X17 a_28_440# B.t6 Y.t14 VNW.t9 pfet_03v3 ad=0.3588p pd=1.9u as=0.3588p ps=1.9u w=1.38u l=0.28u
X18 a_28_68# A.t0 VSS.t1 VPW.t15 nfet_03v3 ad=0.26p pd=1.52u as=0.26p ps=1.52u w=1u l=0.28u
X19 a_28_440# D.t6 VDD.t0 VNW.t1 pfet_03v3 ad=0.3588p pd=1.9u as=0.3588p ps=1.9u w=1.38u l=0.28u
X20 a_28_68# B.t0 Y.t10 VPW.t11 nfet_03v3 ad=0.44p pd=2.88u as=0.26p ps=1.52u w=1u l=0.28u
X21 a_28_440# A.t4 Y.t0 VNW.t15 pfet_03v3 ad=0.3588p pd=1.9u as=0.3588p ps=1.9u w=1.38u l=0.28u
X22 Y.t7 C.t3 a_1436_68# VPW.t4 nfet_03v3 ad=0.26p pd=1.52u as=0.44p ps=2.88u w=1u l=0.28u
X23 VDD.t4 D.t5 a_28_440# VNW.t2 pfet_03v3 ad=0.3588p pd=1.9u as=0.3588p ps=1.9u w=1.38u l=0.28u
X24 VSS.t3 A.t1 a_28_68# VPW.t14 nfet_03v3 ad=0.26p pd=1.52u as=0.26p ps=1.52u w=1u l=0.28u
X25 VSS.t4 D.t1 a_1436_68# VPW.t2 nfet_03v3 ad=0.26p pd=1.52u as=0.26p ps=1.52u w=1u l=0.28u
X26 Y.t12 B.t5 a_28_440# VNW.t10 pfet_03v3 ad=0.3588p pd=1.9u as=0.3588p ps=1.9u w=1.38u l=0.28u
X27 VDD.t7 C.t5 a_28_440# VNW.t6 pfet_03v3 ad=0.3588p pd=1.9u as=0.3588p ps=1.9u w=1.38u l=0.28u
X28 Y.t6 B.t1 a_28_68# VPW.t10 nfet_03v3 ad=0.26p pd=1.52u as=0.26p ps=1.52u w=1u l=0.28u
X29 Y.t2 A.t7 a_28_440# VNW.t12 pfet_03v3 ad=0.3588p pd=1.9u as=0.6072p ps=3.64u w=1.38u l=0.28u
X30 a_1436_68# D.t2 VSS.t5 VPW.t1 nfet_03v3 ad=0.26p pd=1.52u as=0.26p ps=1.52u w=1u l=0.28u
X31 a_28_68# A.t2 VSS.t6 VPW.t13 nfet_03v3 ad=0.26p pd=1.52u as=0.26p ps=1.52u w=1u l=0.28u
R0 VSS.n4 VSS.n3 6.62659
R1 VSS.n4 VSS.n2 6.38659
R2 VSS.n5 VSS.n1 6.38659
R3 VSS.n6 VSS.n0 6.38659
R4 VSS.n3 VSS.t7 1.6385
R5 VSS.n3 VSS.t4 1.6385
R6 VSS.n2 VSS.t5 1.6385
R7 VSS.n2 VSS.t2 1.6385
R8 VSS.n1 VSS.t1 1.6385
R9 VSS.n1 VSS.t3 1.6385
R10 VSS.n0 VSS.t6 1.6385
R11 VSS.n0 VSS.t0 1.6385
R12 VSS.n5 VSS.n4 1.2965
R13 VSS.n6 VSS.n5 0.2405
R14 VSS VSS.n6 0.1685
R15 VDD.n4 VDD.n3 5.52659
R16 VDD.n6 VDD.n0 5.28659
R17 VDD.n5 VDD.n1 5.28659
R18 VDD.n4 VDD.n2 5.28659
R19 VDD.n0 VDD.t5 1.31934
R20 VDD.n0 VDD.t6 1.31934
R21 VDD.n1 VDD.t2 1.31934
R22 VDD.n1 VDD.t7 1.31934
R23 VDD.n2 VDD.t0 1.31934
R24 VDD.n2 VDD.t1 1.31934
R25 VDD.n3 VDD.t3 1.31934
R26 VDD.n3 VDD.t4 1.31934
R27 VDD VDD.n6 1.2245
R28 VDD.n5 VDD.n4 0.2405
R29 VDD.n6 VDD.n5 0.2405
R30 Y.n2 Y.n0 6.92659
R31 Y.n2 Y.n1 6.3005
R32 Y.n4 Y.n3 6.3005
R33 Y.n12 Y.n11 6.3005
R34 Y.n8 Y.n6 5.82659
R35 Y.n10 Y.n5 5.78159
R36 Y.n8 Y.n7 5.2005
R37 Y.n10 Y.n9 5.2005
R38 Y.n11 Y.t15 1.6385
R39 Y.n11 Y.t1 1.6385
R40 Y.n3 Y.t10 1.6385
R41 Y.n3 Y.t6 1.6385
R42 Y.n1 Y.t13 1.6385
R43 Y.n1 Y.t7 1.6385
R44 Y.n0 Y.t8 1.6385
R45 Y.n0 Y.t5 1.6385
R46 Y.n9 Y.t14 1.31934
R47 Y.n9 Y.t9 1.31934
R48 Y.n6 Y.t4 1.31934
R49 Y.n6 Y.t2 1.31934
R50 Y.n7 Y.t0 1.31934
R51 Y.n7 Y.t11 1.31934
R52 Y.n5 Y.t3 1.31934
R53 Y.n5 Y.t12 1.31934
R54 Y.n4 Y.n2 0.877022
R55 Y.n13 Y.n4 0.581587
R56 Y.n10 Y.n8 0.528761
R57 Y.n12 Y.n10 0.408582
R58 Y Y.n13 0.0288562
R59 Y.n13 Y.n12 0.0140616
R60 D.n0 D.t4 24.2469
R61 D.n1 D.t5 24.2469
R62 D.n3 D.t6 24.2469
R63 D.n2 D.t7 24.2469
R64 D.n0 D.t0 19.8148
R65 D.n1 D.t1 19.8148
R66 D.n3 D.t2 19.8148
R67 D.n2 D.t3 19.8148
R68 D.n1 D.n0 16.2227
R69 D.n3 D.n2 16.2227
R70 D.n4 D.n1 8.11161
R71 D.n4 D.n3 8.11161
R72 D D.n4 2.00931
R73 C.n0 C.t4 24.2469
R74 C.n1 C.t5 24.2469
R75 C.n3 C.t6 24.2469
R76 C.n2 C.t7 24.2469
R77 C.n0 C.t0 19.8148
R78 C.n1 C.t1 19.8148
R79 C.n3 C.t2 19.8148
R80 C.n2 C.t3 19.8148
R81 C.n1 C.n0 16.2227
R82 C.n3 C.n2 16.2227
R83 C.n4 C.n1 8.11161
R84 C.n4 C.n3 8.11161
R85 C C.n4 2.00931
R86 B.n0 B.t4 24.2469
R87 B.n3 B.t5 24.2469
R88 B.n2 B.t6 24.2469
R89 B.n1 B.t7 24.2469
R90 B.n0 B.t0 19.8148
R91 B.n3 B.t1 19.8148
R92 B.n2 B.t2 19.8148
R93 B.n1 B.t3 19.8148
R94 B.n3 B.n2 16.2227
R95 B.n2 B.n1 16.2227
R96 B.n4 B.n0 16.0199
R97 B B.n4 2.21675
R98 B.n4 B.n3 0.203278
R99 A.n0 A.t4 24.3773
R100 A.n1 A.t5 24.3773
R101 A.n3 A.t6 24.3773
R102 A.n2 A.t7 24.3773
R103 A.n0 A.t0 19.6844
R104 A.n1 A.t1 19.6844
R105 A.n3 A.t2 19.6844
R106 A.n2 A.t3 19.6844
R107 A.n1 A.n0 16.2227
R108 A.n3 A.n2 16.2227
R109 A.n4 A.n1 9.02411
R110 A.n4 A.n3 7.19911
R111 A A.n4 1.75638
R112 VNW.t11 VNW.t4 558.14
R113 VNW.t2 VNW.t3 310.079
R114 VNW.t1 VNW.t2 310.079
R115 VNW.t0 VNW.t1 310.079
R116 VNW.t7 VNW.t0 310.079
R117 VNW.t6 VNW.t7 310.079
R118 VNW.t5 VNW.t6 310.079
R119 VNW.t4 VNW.t5 310.079
R120 VNW.t10 VNW.t11 310.079
R121 VNW.t9 VNW.t10 310.079
R122 VNW.t8 VNW.t9 310.079
R123 VNW.t15 VNW.t8 310.079
R124 VNW.t14 VNW.t15 310.079
R125 VNW.t13 VNW.t14 310.079
R126 VNW.t12 VNW.t13 310.079
R127 VNW VNW.t12 259.69
R128 VPW.t11 VPW.t4 2127.27
R129 VPW.t2 VPW.t3 1181.82
R130 VPW.t1 VPW.t2 1181.82
R131 VPW.t0 VPW.t1 1181.82
R132 VPW.t7 VPW.t0 1181.82
R133 VPW.t6 VPW.t7 1181.82
R134 VPW.t5 VPW.t6 1181.82
R135 VPW.t4 VPW.t5 1181.82
R136 VPW.t10 VPW.t11 1181.82
R137 VPW.t9 VPW.t10 1181.82
R138 VPW.t8 VPW.t9 1181.82
R139 VPW.t15 VPW.t8 1181.82
R140 VPW.t14 VPW.t15 1181.82
R141 VPW.t13 VPW.t14 1181.82
R142 VPW.t12 VPW.t13 1181.82
R143 VPW VPW.t12 989.774
C0 a_1436_68# VSS 1.10685f
C1 C VSS 0.03708f
C2 VDD A 0.03403f
C3 VNW VSS 0.00778f
C4 Y D 0
C5 a_28_68# Y 0.70768f
C6 B a_28_440# 0.05789f
C7 Y VSS 0.02787f
C8 a_28_68# A 0.32547f
C9 a_1436_68# B 0
C10 C B 0.02463f
C11 B VNW 0.34136f
C12 VSS A 0.0656f
C13 Y B 0.51274f
C14 B A 0.03248f
C15 VDD D 0.07281f
C16 a_28_68# VDD 0
C17 VDD VSS 0.01103f
C18 a_1436_68# a_28_440# 0.03043f
C19 D VSS 0.0665f
C20 a_28_68# VSS 1.15126f
C21 C a_28_440# 0.2241f
C22 VNW a_28_440# 0.12289f
C23 a_1436_68# C 0.06421f
C24 B VDD 0.03538f
C25 a_1436_68# VNW 0.00417f
C26 C VNW 0.34389f
C27 Y a_28_440# 1.35042f
C28 B D 0
C29 a_28_68# B 0.04382f
C30 a_1436_68# Y 0.67763f
C31 Y C 0.29732f
C32 Y VNW 0.0399f
C33 a_28_440# A 0.0683f
C34 B VSS 0.03708f
C35 VNW A 0.34785f
C36 Y A 0.20277f
C37 VDD a_28_440# 2.21306f
C38 a_1436_68# VDD 0
C39 C VDD 0.0729f
C40 VDD VNW 0.32725f
C41 D a_28_440# 0.22612f
C42 a_28_68# a_28_440# 0.01482f
C43 a_1436_68# D 0.36268f
C44 a_1436_68# a_28_68# 0.04569f
C45 C D 0.0624f
C46 a_28_68# C 0
C47 Y VDD 0.00889f
C48 a_28_440# VSS 0
C49 VNW D 0.3452f
C50 a_28_68# VNW 0.00401f
C51 VSS VPW 0.98008f
C52 VDD VPW 1.16506f
C53 Y VPW 0.06182f
C54 D VPW 0.60199f
C55 C VPW 0.58491f
C56 B VPW 0.55927f
C57 A VPW 0.60202f
C58 VNW VPW 4.87362f
C59 a_1436_68# VPW 0.03242f
C60 a_28_68# VPW 0.03173f
C61 a_28_440# VPW 0.07762f
C62 VNW.t3 VPW 0.24806f
C63 VNW.t2 VPW 0.09776f
C64 VNW.t1 VPW 0.09776f
C65 VNW.t0 VPW 0.09776f
C66 VNW.t7 VPW 0.09776f
C67 VNW.t6 VPW 0.09776f
C68 VNW.t5 VPW 0.09776f
C69 VNW.t4 VPW 0.13686f
C70 VNW.t11 VPW 0.13686f
C71 VNW.t10 VPW 0.09776f
C72 VNW.t9 VPW 0.09776f
C73 VNW.t8 VPW 0.09776f
C74 VNW.t15 VPW 0.09776f
C75 VNW.t14 VPW 0.09776f
C76 VNW.t13 VPW 0.09776f
C77 VNW.t12 VPW 0.08982f
C78 A.t5 VPW 0.06214f
C79 A.t1 VPW 0.04358f
C80 A.t4 VPW 0.06214f
C81 A.t0 VPW 0.04358f
C82 A.n0 VPW 0.10204f
C83 A.n1 VPW 0.10907f
C84 A.t6 VPW 0.06214f
C85 A.t2 VPW 0.04358f
C86 A.t7 VPW 0.06214f
C87 A.t3 VPW 0.04358f
C88 A.n2 VPW 0.10971f
C89 A.n3 VPW 0.10523f
C90 A.n4 VPW 0.06901f
C91 B.t4 VPW 0.06544f
C92 B.t0 VPW 0.04619f
C93 B.n0 VPW 0.10729f
C94 B.t5 VPW 0.06544f
C95 B.t1 VPW 0.04619f
C96 B.t6 VPW 0.06544f
C97 B.t2 VPW 0.04619f
C98 B.t7 VPW 0.06544f
C99 B.t3 VPW 0.04619f
C100 B.n1 VPW 0.10774f
C101 B.n2 VPW 0.13113f
C102 B.n3 VPW 0.09559f
C103 B.n4 VPW 0.04796f
C104 C.t5 VPW 0.06534f
C105 C.t1 VPW 0.04612f
C106 C.t4 VPW 0.06534f
C107 C.t0 VPW 0.04612f
C108 C.n0 VPW 0.10757f
C109 C.n1 VPW 0.11296f
C110 C.t6 VPW 0.06534f
C111 C.t2 VPW 0.04612f
C112 C.t7 VPW 0.06534f
C113 C.t3 VPW 0.04612f
C114 C.n2 VPW 0.10757f
C115 C.n3 VPW 0.11296f
C116 C.n4 VPW 0.06741f
C117 D.t5 VPW 0.06628f
C118 D.t1 VPW 0.04678f
C119 D.t4 VPW 0.06628f
C120 D.t0 VPW 0.04678f
C121 D.n0 VPW 0.10911f
C122 D.n1 VPW 0.11458f
C123 D.t6 VPW 0.06628f
C124 D.t2 VPW 0.04678f
C125 D.t7 VPW 0.06628f
C126 D.t3 VPW 0.04678f
C127 D.n2 VPW 0.10911f
C128 D.n3 VPW 0.11458f
C129 D.n4 VPW 0.067f
C130 Y.t8 VPW 0.06185f
C131 Y.t5 VPW 0.06185f
C132 Y.n0 VPW 0.13339f
C133 Y.t13 VPW 0.06185f
C134 Y.t7 VPW 0.06185f
C135 Y.n1 VPW 0.12369f
C136 Y.n2 VPW 0.30763f
C137 Y.t10 VPW 0.06185f
C138 Y.t6 VPW 0.06185f
C139 Y.n3 VPW 0.12369f
C140 Y.n4 VPW 0.2038f
C141 Y.t3 VPW 0.08535f
C142 Y.t12 VPW 0.08535f
C143 Y.n5 VPW 0.18123f
C144 Y.t4 VPW 0.08535f
C145 Y.t2 VPW 0.08535f
C146 Y.n6 VPW 0.18251f
C147 Y.t0 VPW 0.08535f
C148 Y.t11 VPW 0.08535f
C149 Y.n7 VPW 0.1707f
C150 Y.n8 VPW 0.25955f
C151 Y.t14 VPW 0.08535f
C152 Y.t9 VPW 0.08535f
C153 Y.n9 VPW 0.1707f
C154 Y.n10 VPW 0.413f
C155 Y.t15 VPW 0.06185f
C156 Y.t1 VPW 0.06185f
C157 Y.n11 VPW 0.12369f
C158 Y.n12 VPW 0.14846f
C159 Y.n13 VPW 0.09599f
C160 VDD.t5 VPW 0.04162f
C161 VDD.t6 VPW 0.04162f
C162 VDD.n0 VPW 0.08348f
C163 VDD.t2 VPW 0.04162f
C164 VDD.t7 VPW 0.04162f
C165 VDD.n1 VPW 0.08348f
C166 VDD.t0 VPW 0.04162f
C167 VDD.t1 VPW 0.04162f
C168 VDD.n2 VPW 0.08348f
C169 VDD.t3 VPW 0.04162f
C170 VDD.t4 VPW 0.04162f
C171 VDD.n3 VPW 0.09889f
C172 VDD.n4 VPW 0.58253f
C173 VDD.n5 VPW 0.24329f
C174 VDD.n6 VPW 0.69986f
C175 VSS.t6 VPW 0.02922f
C176 VSS.t0 VPW 0.02922f
C177 VSS.n0 VPW 0.05864f
C178 VSS.t1 VPW 0.02922f
C179 VSS.t3 VPW 0.02922f
C180 VSS.n1 VPW 0.05864f
C181 VSS.t5 VPW 0.02922f
C182 VSS.t2 VPW 0.02922f
C183 VSS.n2 VPW 0.05864f
C184 VSS.t7 VPW 0.02922f
C185 VSS.t4 VPW 0.02922f
C186 VSS.n3 VPW 0.07109f
C187 VSS.n4 VPW 1.04172f
C188 VSS.n5 VPW 0.71051f
C189 VSS.n6 VPW 0.20339f
.ends

* NGSPICE file created from gf180mcu_as_sc_mcu7t3v3__aoi31_2.ext - technology: gf180mcuD

.subckt gf180mcu_as_sc_mcu7t3v3__aoi31_2 VDD VNW VPW VSS A B C Y D
X0 a_28_440# A.t2 VDD.t0 VNW.t7 pfet_03v3 ad=0.3588p pd=1.9u as=0.3588p ps=1.9u w=1.38u l=0.28u
X1 VSS.t0 D.t1 Y.t0 VPW.t0 nfet_03v3 ad=0.2625p pd=1.525u as=0.26p ps=1.52u w=1u l=0.28u
X2 VSS.t2 A.t1 a_28_68# VPW.t6 nfet_03v3 ad=0.26p pd=1.52u as=0.44p ps=2.88u w=1u l=0.28u
X3 a_28_440# C.t2 VDD.t3 VNW.t3 pfet_03v3 ad=0.3588p pd=1.9u as=0.3588p ps=1.9u w=1.38u l=0.28u
X4 Y.t4 C.t0 a_492_68# VPW.t3 nfet_03v3 ad=0.26p pd=1.52u as=0.26p ps=1.52u w=1u l=0.28u
X5 VDD.t1 B.t3 a_28_440# VNW.t4 pfet_03v3 ad=0.3588p pd=1.9u as=0.3588p ps=1.9u w=1.38u l=0.28u
X6 a_28_68# B.t0 a_492_68# VPW.t5 nfet_03v3 ad=0.44p pd=2.88u as=0.26p ps=1.52u w=1u l=0.28u
X7 Y.t1 D.t3 a_28_440# VNW.t0 pfet_03v3 ad=0.36225p pd=1.905u as=0.3588p ps=1.9u w=1.38u l=0.28u
X8 a_28_440# B.t2 VDD.t4 VNW.t5 pfet_03v3 ad=0.8004p pd=2.54u as=0.3588p ps=1.9u w=1.38u l=0.28u
X9 VDD.t5 C.t3 a_28_440# VNW.t2 pfet_03v3 ad=0.3588p pd=1.9u as=0.8004p ps=2.54u w=1.38u l=0.28u
X10 a_492_68# C.t1 Y.t2 VPW.t2 nfet_03v3 ad=0.26p pd=1.52u as=0.44p ps=2.88u w=1u l=0.28u
X11 a_492_68# B.t1 a_28_68# VPW.t4 nfet_03v3 ad=0.26p pd=1.52u as=0.26p ps=1.52u w=1u l=0.28u
X12 Y.t3 D.t0 VSS.t3 VPW.t1 nfet_03v3 ad=0.44p pd=2.88u as=0.2625p ps=1.525u w=1u l=0.28u
X13 VDD.t2 A.t3 a_28_440# VNW.t6 pfet_03v3 ad=0.3588p pd=1.9u as=0.6072p ps=3.64u w=1.38u l=0.28u
X14 a_28_440# D.t2 Y.t5 VNW.t1 pfet_03v3 ad=0.6072p pd=3.64u as=0.36225p ps=1.905u w=1.38u l=0.28u
X15 a_28_68# A.t0 VSS.t1 VPW.t7 nfet_03v3 ad=0.26p pd=1.52u as=0.26p ps=1.52u w=1u l=0.28u
R0 VSS.n2 VSS.n1 7.20334
R1 VSS.n2 VSS.n0 6.38659
R2 VSS.n1 VSS.t0 1.67
R3 VSS.n1 VSS.t3 1.6385
R4 VSS.n0 VSS.t1 1.6385
R5 VSS.n0 VSS.t2 1.6385
R6 VSS VSS.n2 0.1685
R7 Y.n3 Y.t3 10.2318
R8 Y.n1 Y.t2 8.61546
R9 Y.n1 Y.n0 6.3005
R10 Y.n3 Y.n2 5.68507
R11 Y.n0 Y.t0 1.6385
R12 Y.n0 Y.t4 1.6385
R13 Y.n2 Y.t1 1.3447
R14 Y.n2 Y.t5 1.31934
R15 Y.n3 Y.n1 0.419196
R16 Y Y.n3 0.0368158
R17 VDD.n3 VDD.n2 5.62259
R18 VDD.n4 VDD.n0 5.28659
R19 VDD.n3 VDD.n1 5.28659
R20 VDD.n0 VDD.t0 1.31934
R21 VDD.n0 VDD.t2 1.31934
R22 VDD.n1 VDD.t4 1.31934
R23 VDD.n1 VDD.t1 1.31934
R24 VDD.n2 VDD.t3 1.31934
R25 VDD.n2 VDD.t5 1.31934
R26 VDD.n4 VDD.n3 0.2405
R27 VDD VDD.n4 0.1685
R28 D.n0 D.t2 24.3773
R29 D.n1 D.t3 24.3773
R30 D.n0 D.t0 19.6844
R31 D.n1 D.t1 19.6844
R32 D.n2 D.n0 15.3102
R33 D D.n2 8.09203
R34 D.n2 D.n1 1.01439
R35 C.n0 C.t2 24.3773
R36 C.n1 C.t3 24.3773
R37 C.n0 C.t0 19.6844
R38 C.n1 C.t1 19.6844
R39 C.n2 C.n1 12.3699
R40 C C.n2 8.22931
R41 C.n2 C.n0 3.85328
R42 B.n0 B.t2 24.3773
R43 B.n1 B.t3 24.3773
R44 B.n0 B.t0 19.6844
R45 B.n1 B.t1 19.6844
R46 B.n2 B.n0 9.1255
R47 B B.n2 8.14999
R48 B.n2 B.n1 7.09772
R49 A.n0 A.t2 24.3773
R50 A.n1 A.t3 24.3773
R51 A.n0 A.t0 19.6844
R52 A.n1 A.t1 19.6844
R53 A.n2 A.n1 8.31439
R54 A A.n2 8.1683
R55 A.n2 A.n0 7.90883
R56 VNW.t5 VNW.t2 558.14
R57 VNW.t0 VNW.t1 312.017
R58 VNW.t3 VNW.t0 310.079
R59 VNW.t2 VNW.t3 310.079
R60 VNW.t4 VNW.t5 310.079
R61 VNW.t7 VNW.t4 310.079
R62 VNW.t6 VNW.t7 310.079
R63 VNW VNW.t6 259.69
R64 VPW.t5 VPW.t2 2127.27
R65 VPW.t0 VPW.t1 1189.2
R66 VPW.t3 VPW.t0 1181.82
R67 VPW.t2 VPW.t3 1181.82
R68 VPW.t4 VPW.t5 1181.82
R69 VPW.t7 VPW.t4 1181.82
R70 VPW.t6 VPW.t7 1181.82
R71 VPW VPW.t6 989.774
C0 a_28_440# VSS 0
C1 B a_492_68# 0.10202f
C2 a_28_440# C 0.10806f
C3 B a_28_68# 0.03754f
C4 B VNW 0.16429f
C5 B A 0.05612f
C6 VSS a_492_68# 0.02345f
C7 VSS a_28_68# 0.61642f
C8 VSS VNW 0.00445f
C9 VSS A 0.03083f
C10 C a_492_68# 0.09325f
C11 C a_28_68# 0
C12 VNW C 0.16334f
C13 VDD D 0.01823f
C14 a_28_440# a_492_68# 0.04351f
C15 Y D 0.21896f
C16 a_28_440# a_28_68# 0.03465f
C17 a_28_440# VNW 0.15983f
C18 a_28_440# A 0.10907f
C19 B VDD 0.0355f
C20 B Y 0.00114f
C21 a_28_68# a_492_68# 0.30932f
C22 VNW a_492_68# 0.0061f
C23 VSS VDD 0.00632f
C24 A a_492_68# 0
C25 VSS Y 0.59561f
C26 VNW a_28_68# 0.00444f
C27 A a_28_68# 0.13255f
C28 VNW A 0.16301f
C29 VDD C 0.03462f
C30 Y C 0.04525f
C31 a_28_440# VDD 1.17227f
C32 a_28_440# Y 0.20854f
C33 Y a_492_68# 0.29827f
C34 VSS D 0.03092f
C35 VDD a_28_68# 0
C36 VDD VNW 0.18577f
C37 Y a_28_68# 0.04584f
C38 VDD A 0.03434f
C39 VNW Y 0.02223f
C40 Y A 0
C41 C D 0.06649f
C42 B VSS 0.01905f
C43 B C 0.02376f
C44 a_28_440# D 0.05938f
C45 B a_28_440# 0.10907f
C46 VSS C 0.01905f
C47 VDD Y 0.00362f
C48 VNW D 0.16794f
C49 VSS VPW 0.59699f
C50 Y VPW 0.07405f
C51 VDD VPW 0.41552f
C52 D VPW 0.26504f
C53 C VPW 0.27786f
C54 B VPW 0.2782f
C55 A VPW 0.2989f
C56 VNW VPW 2.79108f
C57 a_492_68# VPW 0.0163f
C58 a_28_68# VPW 0.02614f
C59 a_28_440# VPW 0.08432f
C60 VNW.t1 VPW 0.20439f
C61 VNW.t0 VPW 0.09606f
C62 VNW.t3 VPW 0.09576f
C63 VNW.t2 VPW 0.13407f
C64 VNW.t5 VPW 0.13407f
C65 VNW.t4 VPW 0.09576f
C66 VNW.t7 VPW 0.09576f
C67 VNW.t6 VPW 0.08798f
C68 A.t2 VPW 0.06668f
C69 A.t0 VPW 0.04676f
C70 A.n0 VPW 0.09073f
C71 A.t3 VPW 0.06668f
C72 A.t1 VPW 0.04676f
C73 A.n1 VPW 0.09164f
C74 A.n2 VPW 0.03782f
C75 B.t2 VPW 0.06943f
C76 B.t0 VPW 0.04869f
C77 B.n0 VPW 0.09733f
C78 B.t3 VPW 0.06943f
C79 B.t1 VPW 0.04869f
C80 B.n1 VPW 0.09257f
C81 B.n2 VPW 0.03928f
C82 C.t2 VPW 0.07015f
C83 C.t0 VPW 0.0492f
C84 C.n0 VPW 0.08584f
C85 C.t3 VPW 0.07015f
C86 C.t1 VPW 0.0492f
C87 C.n1 VPW 0.10605f
C88 C.n2 VPW 0.04003f
C89 D.t2 VPW 0.07485f
C90 D.t0 VPW 0.05249f
C91 D.n0 VPW 0.12059f
C92 D.t3 VPW 0.07485f
C93 D.t1 VPW 0.05249f
C94 D.n1 VPW 0.09569f
C95 D.n2 VPW 0.04174f
C96 VDD.t0 VPW 0.03754f
C97 VDD.t2 VPW 0.03754f
C98 VDD.n0 VPW 0.07529f
C99 VDD.t4 VPW 0.03754f
C100 VDD.t1 VPW 0.03754f
C101 VDD.n1 VPW 0.07529f
C102 VDD.t3 VPW 0.03754f
C103 VDD.t5 VPW 0.03754f
C104 VDD.n2 VPW 0.10641f
C105 VDD.n3 VPW 0.74916f
C106 VDD.n4 VPW 0.18928f
C107 Y.t2 VPW 0.16394f
C108 Y.t0 VPW 0.05324f
C109 Y.t4 VPW 0.05324f
C110 Y.n0 VPW 0.10649f
C111 Y.n1 VPW 0.26818f
C112 Y.t3 VPW 0.15608f
C113 Y.t5 VPW 0.07348f
C114 Y.t1 VPW 0.07489f
C115 Y.n2 VPW 0.15801f
C116 Y.n3 VPW 0.32557f
C117 VSS.t1 VPW 0.02953f
C118 VSS.t2 VPW 0.02953f
C119 VSS.n0 VPW 0.05926f
C120 VSS.t3 VPW 0.02953f
C121 VSS.t0 VPW 0.0301f
C122 VSS.n1 VPW 0.12389f
C123 VSS.n2 VPW 0.96847f
.ends

* NGSPICE file created from gf180mcu_as_sc_mcu7t3v3__aoi31_4.ext - technology: gf180mcuD

.subckt gf180mcu_as_sc_mcu7t3v3__aoi31_4 VDD VNW VPW VSS A B C D Y
X0 a_28_440# C.t4 VDD.t7 VNW.t7 pfet_03v3 ad=0.3588p pd=1.9u as=0.3588p ps=1.9u w=1.38u l=0.28u
X1 a_28_68# B.t2 a_812_68# VPW.t9 nfet_03v3 ad=0.26p pd=1.52u as=0.26p ps=1.52u w=1u l=0.28u
X2 a_28_440# A.t6 VDD.t4 VNW.t13 pfet_03v3 ad=0.3588p pd=1.9u as=0.3588p ps=1.9u w=1.38u l=0.28u
X3 VDD.t2 B.t7 a_28_440# VNW.t8 pfet_03v3 ad=0.3588p pd=1.9u as=0.3588p ps=1.9u w=1.38u l=0.28u
X4 Y.t11 D.t7 a_28_440# VNW.t0 pfet_03v3 ad=0.3588p pd=1.9u as=0.3588p ps=1.9u w=1.38u l=0.28u
X5 VSS.t1 A.t3 a_28_68# VPW.t12 nfet_03v3 ad=0.26p pd=1.52u as=0.44p ps=2.88u w=1u l=0.28u
X6 VSS.t3 D.t3 Y.t5 VPW.t0 nfet_03v3 ad=0.26p pd=1.52u as=0.26p ps=1.52u w=1u l=0.28u
X7 a_28_440# D.t4 Y.t0 VNW.t3 pfet_03v3 ad=1.2696p pd=4.6u as=0.3588p ps=1.9u w=1.38u l=0.28u
X8 a_28_440# B.t4 VDD.t6 VNW.t11 pfet_03v3 ad=0.8004p pd=2.54u as=0.3588p ps=1.9u w=1.38u l=0.28u
X9 VDD.t8 C.t7 a_28_440# VNW.t4 pfet_03v3 ad=0.3588p pd=1.9u as=0.8004p ps=2.54u w=1.38u l=0.28u
X10 a_812_68# C.t1 Y.t3 VPW.t6 nfet_03v3 ad=0.26p pd=1.52u as=0.26p ps=1.52u w=1u l=0.28u
X11 a_812_68# B.t3 a_28_68# VPW.t8 nfet_03v3 ad=0.26p pd=1.52u as=0.26p ps=1.52u w=1u l=0.28u
X12 Y.t2 C.t0 a_812_68# VPW.t7 nfet_03v3 ad=0.26p pd=1.52u as=0.26p ps=1.52u w=1u l=0.28u
X13 a_28_440# C.t6 VDD.t10 VNW.t5 pfet_03v3 ad=0.3588p pd=1.9u as=0.3588p ps=1.9u w=1.38u l=0.28u
X14 VDD.t9 A.t5 a_28_440# VNW.t14 pfet_03v3 ad=0.3588p pd=1.9u as=0.3588p ps=1.9u w=1.38u l=0.28u
X15 Y.t8 C.t2 a_812_68# VPW.t5 nfet_03v3 ad=0.26p pd=1.52u as=0.26p ps=1.52u w=1u l=0.28u
X16 Y.t10 D.t0 VSS.t6 VPW.t3 nfet_03v3 ad=0.44p pd=2.88u as=0.26p ps=1.52u w=1u l=0.28u
X17 a_28_440# B.t6 VDD.t3 VNW.t9 pfet_03v3 ad=0.3588p pd=1.9u as=0.3588p ps=1.9u w=1.38u l=0.28u
X18 a_28_68# A.t0 VSS.t2 VPW.t15 nfet_03v3 ad=0.26p pd=1.52u as=0.26p ps=1.52u w=1u l=0.28u
X19 a_28_440# D.t6 Y.t4 VNW.t1 pfet_03v3 ad=0.3588p pd=1.9u as=0.3588p ps=1.9u w=1.38u l=0.28u
X20 a_28_68# B.t0 a_812_68# VPW.t11 nfet_03v3 ad=0.44p pd=2.88u as=0.26p ps=1.52u w=1u l=0.28u
X21 a_28_440# A.t4 VDD.t0 VNW.t15 pfet_03v3 ad=0.3588p pd=1.9u as=0.3588p ps=1.9u w=1.38u l=0.28u
X22 a_812_68# C.t3 Y.t9 VPW.t4 nfet_03v3 ad=0.26p pd=1.52u as=0.44p ps=2.88u w=1u l=0.28u
X23 Y.t6 D.t5 a_28_440# VNW.t2 pfet_03v3 ad=0.3588p pd=1.9u as=0.3588p ps=1.9u w=1.38u l=0.28u
X24 VSS.t7 A.t1 a_28_68# VPW.t14 nfet_03v3 ad=0.26p pd=1.52u as=0.26p ps=1.52u w=1u l=0.28u
X25 VSS.t0 D.t1 Y.t1 VPW.t2 nfet_03v3 ad=0.26p pd=1.52u as=0.26p ps=1.52u w=1u l=0.28u
X26 VDD.t1 B.t5 a_28_440# VNW.t10 pfet_03v3 ad=0.3588p pd=1.9u as=0.3588p ps=1.9u w=1.38u l=0.28u
X27 VDD.t5 C.t5 a_28_440# VNW.t6 pfet_03v3 ad=0.3588p pd=1.9u as=0.3588p ps=1.9u w=1.38u l=0.28u
X28 a_812_68# B.t1 a_28_68# VPW.t10 nfet_03v3 ad=0.26p pd=1.52u as=0.26p ps=1.52u w=1u l=0.28u
X29 VDD.t11 A.t7 a_28_440# VNW.t12 pfet_03v3 ad=0.3588p pd=1.9u as=0.6072p ps=3.64u w=1.38u l=0.28u
X30 Y.t7 D.t2 VSS.t4 VPW.t1 nfet_03v3 ad=0.26p pd=1.52u as=0.26p ps=1.52u w=1u l=0.28u
X31 a_28_68# A.t2 VSS.t5 VPW.t13 nfet_03v3 ad=0.26p pd=1.52u as=0.26p ps=1.52u w=1u l=0.28u
R0 VSS.n4 VSS.n3 6.62659
R1 VSS.n4 VSS.n2 6.38659
R2 VSS.n5 VSS.n1 6.38659
R3 VSS.n6 VSS.n0 6.38659
R4 VSS.n3 VSS.t6 1.6385
R5 VSS.n3 VSS.t0 1.6385
R6 VSS.n2 VSS.t4 1.6385
R7 VSS.n2 VSS.t3 1.6385
R8 VSS.n1 VSS.t2 1.6385
R9 VSS.n1 VSS.t7 1.6385
R10 VSS.n0 VSS.t5 1.6385
R11 VSS.n0 VSS.t1 1.6385
R12 VSS.n5 VSS.n4 1.2965
R13 VSS.n6 VSS.n5 0.2405
R14 VSS VSS.n6 0.1685
R15 Y.n1 Y.t9 10.7209
R16 Y.n9 Y.t10 10.0948
R17 Y.n5 Y.n4 6.3005
R18 Y.n3 Y.n2 6.3005
R19 Y.n1 Y.n0 6.3005
R20 Y.n8 Y.n6 5.82659
R21 Y.n8 Y.n7 5.2005
R22 Y.n0 Y.t3 1.6385
R23 Y.n0 Y.t8 1.6385
R24 Y.n2 Y.t5 1.6385
R25 Y.n2 Y.t2 1.6385
R26 Y.n4 Y.t1 1.6385
R27 Y.n4 Y.t7 1.6385
R28 Y.n6 Y.t4 1.31934
R29 Y.n6 Y.t11 1.31934
R30 Y.n7 Y.t0 1.31934
R31 Y.n7 Y.t6 1.31934
R32 Y.n9 Y.n8 0.745935
R33 Y.n5 Y.n3 0.626587
R34 Y.n3 Y.n1 0.626587
R35 Y.n9 Y.n5 0.612891
R36 Y Y.n9 0.0305
R37 VDD.n6 VDD.n5 5.52659
R38 VDD.n10 VDD.n0 5.28659
R39 VDD.n9 VDD.n1 5.28659
R40 VDD.n8 VDD.n2 5.28659
R41 VDD.n7 VDD.n3 5.28659
R42 VDD.n6 VDD.n4 5.28659
R43 VDD.n0 VDD.t4 1.31934
R44 VDD.n0 VDD.t11 1.31934
R45 VDD.n1 VDD.t0 1.31934
R46 VDD.n1 VDD.t9 1.31934
R47 VDD.n2 VDD.t3 1.31934
R48 VDD.n2 VDD.t2 1.31934
R49 VDD.n3 VDD.t6 1.31934
R50 VDD.n3 VDD.t1 1.31934
R51 VDD.n4 VDD.t10 1.31934
R52 VDD.n4 VDD.t8 1.31934
R53 VDD.n5 VDD.t7 1.31934
R54 VDD.n5 VDD.t5 1.31934
R55 VDD.n7 VDD.n6 0.3365
R56 VDD.n8 VDD.n7 0.2405
R57 VDD.n9 VDD.n8 0.2405
R58 VDD.n10 VDD.n9 0.2405
R59 VDD VDD.n10 0.1685
R60 D.n0 D.t4 24.5076
R61 D.n1 D.t5 24.5076
R62 D.n3 D.t6 24.5076
R63 D.n2 D.t7 24.5076
R64 D.n0 D.t0 19.5541
R65 D.n1 D.t1 19.5541
R66 D.n3 D.t2 19.5541
R67 D.n2 D.t3 19.5541
R68 D.n1 D.n0 16.2227
R69 D.n3 D.n2 16.2227
R70 D.n4 D.n1 8.11161
R71 D.n4 D.n3 8.11161
R72 D D.n4 1.9355
R73 C.n0 C.t4 24.5076
R74 C.n1 C.t5 24.5076
R75 C.n3 C.t6 24.5076
R76 C.n2 C.t7 24.5076
R77 C.n0 C.t0 19.5541
R78 C.n1 C.t1 19.5541
R79 C.n3 C.t2 19.5541
R80 C.n2 C.t3 19.5541
R81 C.n1 C.n0 16.2227
R82 C.n3 C.n2 16.2227
R83 C.n4 C.n1 8.11161
R84 C.n4 C.n3 8.11161
R85 C C.n4 1.9355
R86 B.n0 B.t4 24.5076
R87 B.n1 B.t5 24.5076
R88 B.n3 B.t6 24.5076
R89 B.n2 B.t7 24.5076
R90 B.n0 B.t0 19.5541
R91 B.n1 B.t1 19.5541
R92 B.n3 B.t2 19.5541
R93 B.n2 B.t3 19.5541
R94 B.n1 B.n0 16.2227
R95 B.n3 B.n2 16.2227
R96 B.n4 B.n1 8.11161
R97 B.n4 B.n3 8.11161
R98 B B.n4 1.9355
R99 A.n0 A.t4 24.5076
R100 A.n1 A.t5 24.5076
R101 A.n3 A.t6 24.5076
R102 A.n2 A.t7 24.5076
R103 A.n0 A.t0 19.5541
R104 A.n1 A.t1 19.5541
R105 A.n3 A.t2 19.5541
R106 A.n2 A.t3 19.5541
R107 A.n1 A.n0 16.2227
R108 A.n3 A.n2 16.2227
R109 A.n4 A.n1 9.22689
R110 A.n4 A.n3 6.99633
R111 A A.n4 1.73883
R112 VNW.t11 VNW.t4 558.14
R113 VNW.t2 VNW.t3 310.079
R114 VNW.t1 VNW.t2 310.079
R115 VNW.t0 VNW.t1 310.079
R116 VNW.t7 VNW.t0 310.079
R117 VNW.t6 VNW.t7 310.079
R118 VNW.t5 VNW.t6 310.079
R119 VNW.t4 VNW.t5 310.079
R120 VNW.t10 VNW.t11 310.079
R121 VNW.t9 VNW.t10 310.079
R122 VNW.t8 VNW.t9 310.079
R123 VNW.t15 VNW.t8 310.079
R124 VNW.t14 VNW.t15 310.079
R125 VNW.t13 VNW.t14 310.079
R126 VNW.t12 VNW.t13 310.079
R127 VNW VNW.t12 259.69
R128 VPW.t11 VPW.t4 2127.27
R129 VPW.t2 VPW.t3 1181.82
R130 VPW.t1 VPW.t2 1181.82
R131 VPW.t0 VPW.t1 1181.82
R132 VPW.t7 VPW.t0 1181.82
R133 VPW.t6 VPW.t7 1181.82
R134 VPW.t5 VPW.t6 1181.82
R135 VPW.t4 VPW.t5 1181.82
R136 VPW.t10 VPW.t11 1181.82
R137 VPW.t9 VPW.t10 1181.82
R138 VPW.t8 VPW.t9 1181.82
R139 VPW.t15 VPW.t8 1181.82
R140 VPW.t14 VPW.t15 1181.82
R141 VPW.t13 VPW.t14 1181.82
R142 VPW.t12 VPW.t13 1181.82
R143 VPW VPW.t12 989.774
C0 a_28_440# VSS 0.00285f
C1 C VNW 0.34408f
C2 VSS VDD 0.00861f
C3 a_812_68# VSS 1.34153f
C4 a_28_440# VDD 2.17962f
C5 a_812_68# a_28_440# 0.00676f
C6 D a_28_68# 0
C7 A a_28_68# 0.33186f
C8 C VSS 0.04092f
C9 a_28_440# C 0.28031f
C10 Y a_28_68# 0.04366f
C11 C VDD 0.07062f
C12 a_812_68# C 0.02747f
C13 Y D 0.66682f
C14 a_28_68# B 0.38133f
C15 A B 0.05898f
C16 VNW a_28_68# 0.0063f
C17 D VNW 0.34359f
C18 A VNW 0.34959f
C19 Y B 0
C20 Y VNW 0.04143f
C21 VNW B 0.3441f
C22 VSS a_28_68# 0.43829f
C23 a_28_440# a_28_68# 0.0486f
C24 D VSS 0.06656f
C25 D a_28_440# 0.05911f
C26 VSS A 0.06567f
C27 a_28_440# A 0.28942f
C28 VDD a_28_68# 0
C29 a_812_68# a_28_68# 0.66581f
C30 D VDD 0.03595f
C31 a_812_68# D 0.00118f
C32 Y VSS 0.35597f
C33 Y a_28_440# 0.72791f
C34 A VDD 0.07042f
C35 a_812_68# A 0.00128f
C36 VSS B 0.04092f
C37 a_28_440# B 0.29061f
C38 Y VDD 0.01414f
C39 a_812_68# Y 0.65437f
C40 VSS VNW 0.00409f
C41 C a_28_68# 0
C42 a_28_440# VNW 0.21104f
C43 VDD B 0.0715f
C44 a_812_68# B 0.02764f
C45 D C 0.06173f
C46 VNW VDD 0.32699f
C47 a_812_68# VNW 0.00111f
C48 Y C 0.38147f
C49 C B 0.02614f
C50 VSS VPW 0.96828f
C51 Y VPW 0.1089f
C52 VDD VPW 0.66628f
C53 D VPW 0.6465f
C54 C VPW 0.63456f
C55 B VPW 0.63658f
C56 A VPW 0.62729f
C57 VNW VPW 4.87827f
C58 a_812_68# VPW 0.00935f
C59 a_28_68# VPW 0.04679f
C60 a_28_440# VPW 0.05668f
C61 VNW.t3 VPW 0.25965f
C62 VNW.t2 VPW 0.10232f
C63 VNW.t1 VPW 0.10232f
C64 VNW.t0 VPW 0.10232f
C65 VNW.t7 VPW 0.10232f
C66 VNW.t6 VPW 0.10232f
C67 VNW.t5 VPW 0.10232f
C68 VNW.t4 VPW 0.14326f
C69 VNW.t11 VPW 0.14326f
C70 VNW.t10 VPW 0.10232f
C71 VNW.t9 VPW 0.10232f
C72 VNW.t8 VPW 0.10232f
C73 VNW.t15 VPW 0.10232f
C74 VNW.t14 VPW 0.10232f
C75 VNW.t13 VPW 0.10232f
C76 VNW.t12 VPW 0.09401f
C77 A.t5 VPW 0.06671f
C78 A.t1 VPW 0.04648f
C79 A.t4 VPW 0.06671f
C80 A.t0 VPW 0.04648f
C81 A.n0 VPW 0.10969f
C82 A.n1 VPW 0.11722f
C83 A.t6 VPW 0.06671f
C84 A.t2 VPW 0.04648f
C85 A.t7 VPW 0.06671f
C86 A.t3 VPW 0.04648f
C87 A.n2 VPW 0.11927f
C88 A.n3 VPW 0.1122f
C89 A.n4 VPW 0.07489f
C90 B.t5 VPW 0.07007f
C91 B.t1 VPW 0.04883f
C92 B.t4 VPW 0.07007f
C93 B.t0 VPW 0.04883f
C94 B.n0 VPW 0.11475f
C95 B.n1 VPW 0.1205f
C96 B.t6 VPW 0.07007f
C97 B.t2 VPW 0.04883f
C98 B.t7 VPW 0.07007f
C99 B.t3 VPW 0.04883f
C100 B.n2 VPW 0.11475f
C101 B.n3 VPW 0.1205f
C102 B.n4 VPW 0.07169f
C103 C.t5 VPW 0.0696f
C104 C.t1 VPW 0.0485f
C105 C.t4 VPW 0.0696f
C106 C.t0 VPW 0.0485f
C107 C.n0 VPW 0.11397f
C108 C.n1 VPW 0.11968f
C109 C.t6 VPW 0.0696f
C110 C.t2 VPW 0.0485f
C111 C.t7 VPW 0.0696f
C112 C.t3 VPW 0.0485f
C113 C.n2 VPW 0.11397f
C114 C.n3 VPW 0.11968f
C115 C.n4 VPW 0.0712f
C116 D.t5 VPW 0.06974f
C117 D.t1 VPW 0.0486f
C118 D.t4 VPW 0.06974f
C119 D.t0 VPW 0.0486f
C120 D.n0 VPW 0.11421f
C121 D.n1 VPW 0.11993f
C122 D.t6 VPW 0.06974f
C123 D.t2 VPW 0.0486f
C124 D.t7 VPW 0.06974f
C125 D.t3 VPW 0.0486f
C126 D.n2 VPW 0.11421f
C127 D.n3 VPW 0.11993f
C128 D.n4 VPW 0.07127f
C129 VDD.t4 VPW 0.0367f
C130 VDD.t11 VPW 0.0367f
C131 VDD.n0 VPW 0.07362f
C132 VDD.t0 VPW 0.0367f
C133 VDD.t9 VPW 0.0367f
C134 VDD.n1 VPW 0.07362f
C135 VDD.t3 VPW 0.0367f
C136 VDD.t2 VPW 0.0367f
C137 VDD.n2 VPW 0.07362f
C138 VDD.t6 VPW 0.0367f
C139 VDD.t1 VPW 0.0367f
C140 VDD.n3 VPW 0.07362f
C141 VDD.t10 VPW 0.0367f
C142 VDD.t8 VPW 0.0367f
C143 VDD.n4 VPW 0.07362f
C144 VDD.t7 VPW 0.0367f
C145 VDD.t5 VPW 0.0367f
C146 VDD.n5 VPW 0.10426f
C147 VDD.n6 VPW 0.92869f
C148 VDD.n7 VPW 0.25381f
C149 VDD.n8 VPW 0.21453f
C150 VDD.n9 VPW 0.21453f
C151 VDD.n10 VPW 0.18507f
C152 Y.t9 VPW 0.17223f
C153 Y.t3 VPW 0.0565f
C154 Y.t8 VPW 0.0565f
C155 Y.n0 VPW 0.113f
C156 Y.n1 VPW 0.27942f
C157 Y.t5 VPW 0.0565f
C158 Y.t2 VPW 0.0565f
C159 Y.n2 VPW 0.113f
C160 Y.n3 VPW 0.15995f
C161 Y.t1 VPW 0.0565f
C162 Y.t7 VPW 0.0565f
C163 Y.n4 VPW 0.113f
C164 Y.n5 VPW 0.1582f
C165 Y.t4 VPW 0.07797f
C166 Y.t11 VPW 0.07797f
C167 Y.n6 VPW 0.16642f
C168 Y.t0 VPW 0.07797f
C169 Y.t6 VPW 0.07797f
C170 Y.n7 VPW 0.15595f
C171 Y.n8 VPW 0.31512f
C172 Y.t10 VPW 0.16482f
C173 Y.n9 VPW 0.31523f
C174 VSS.t5 VPW 0.02752f
C175 VSS.t1 VPW 0.02752f
C176 VSS.n0 VPW 0.05522f
C177 VSS.t2 VPW 0.02752f
C178 VSS.t7 VPW 0.02752f
C179 VSS.n1 VPW 0.05522f
C180 VSS.t4 VPW 0.02752f
C181 VSS.t3 VPW 0.02752f
C182 VSS.n2 VPW 0.05522f
C183 VSS.t6 VPW 0.02752f
C184 VSS.t0 VPW 0.02752f
C185 VSS.n3 VPW 0.06694f
C186 VSS.n4 VPW 0.98096f
C187 VSS.n5 VPW 0.66907f
C188 VSS.n6 VPW 0.19153f
.ends

* NGSPICE file created from gf180mcu_as_sc_mcu7t3v3__buff_12.ext - technology: gf180mcuD

.subckt gf180mcu_as_sc_mcu7t3v3__buff_12 VDD VNW VPW VSS A Y
X0 VSS.t14 a_172_68# Y.t21 VPW.t15 nfet_03v3 ad=0.985p pd=3.97u as=0.26p ps=1.52u w=1u l=0.28u
X1 VSS.t5 a_172_68# Y.t11 VPW.t5 nfet_03v3 ad=0.26p pd=1.52u as=0.26p ps=1.52u w=1u l=0.28u
X2 VDD.t1 A.t6 a_172_68# VNW.t1 pfet_03v3 ad=0.3588p pd=1.9u as=0.3588p ps=1.9u w=1.38u l=0.28u
X3 Y.t4 a_172_68# VDD.t4 VNW.t4 pfet_03v3 ad=0.3588p pd=1.9u as=0.3588p ps=1.9u w=1.38u l=0.28u
X4 Y.t5 a_172_68# VDD.t12 VNW.t12 pfet_03v3 ad=0.3588p pd=1.9u as=0.3588p ps=1.9u w=1.38u l=0.28u
X5 VDD.t15 a_172_68# Y.t2 VNW.t15 pfet_03v3 ad=1.3593p pd=4.73u as=0.3588p ps=1.9u w=1.38u l=0.28u
X6 a_172_68# A.t3 VSS.t2 VPW.t0 nfet_03v3 ad=0.26p pd=1.52u as=0.44p ps=2.88u w=1u l=0.28u
X7 VSS.t6 a_172_68# Y.t15 VPW.t9 nfet_03v3 ad=0.26p pd=1.52u as=0.26p ps=1.52u w=1u l=0.28u
X8 VDD.t7 a_172_68# Y.t3 VNW.t7 pfet_03v3 ad=0.3588p pd=1.9u as=0.3588p ps=1.9u w=1.38u l=0.28u
X9 Y.t0 a_172_68# VDD.t10 VNW.t10 pfet_03v3 ad=0.36915p pd=1.915u as=0.3588p ps=1.9u w=1.38u l=0.28u
X10 VDD.t13 a_172_68# Y.t6 VNW.t13 pfet_03v3 ad=0.3588p pd=1.9u as=0.3588p ps=1.9u w=1.38u l=0.28u
X11 Y.t20 a_172_68# VSS.t8 VPW.t14 nfet_03v3 ad=0.26p pd=1.52u as=0.26p ps=1.52u w=1u l=0.28u
X12 Y.t10 a_172_68# VSS.t11 VPW.t4 nfet_03v3 ad=0.26p pd=1.52u as=0.26p ps=1.52u w=1u l=0.28u
X13 Y.t22 a_172_68# VDD.t8 VNW.t8 pfet_03v3 ad=0.3588p pd=1.9u as=0.3588p ps=1.9u w=1.38u l=0.28u
X14 Y.t14 a_172_68# VSS.t15 VPW.t8 nfet_03v3 ad=0.26p pd=1.52u as=0.26p ps=1.52u w=1u l=0.28u
X15 a_172_68# A.t5 VDD.t0 VNW.t2 pfet_03v3 ad=0.3588p pd=1.9u as=0.3588p ps=1.9u w=1.38u l=0.28u
X16 VSS.t12 a_172_68# Y.t19 VPW.t13 nfet_03v3 ad=0.26p pd=1.52u as=0.26p ps=1.52u w=1u l=0.28u
X17 VDD.t5 a_172_68# Y.t8 VNW.t5 pfet_03v3 ad=0.3588p pd=1.9u as=0.3588p ps=1.9u w=1.38u l=0.28u
X18 VSS.t3 A.t0 a_172_68# VPW.t3 nfet_03v3 ad=0.26p pd=1.52u as=0.26p ps=1.52u w=1u l=0.28u
X19 VSS.t7 a_172_68# Y.t13 VPW.t7 nfet_03v3 ad=0.26p pd=1.52u as=0.26p ps=1.52u w=1u l=0.28u
X20 VSS.t10 a_172_68# Y.t17 VPW.t11 nfet_03v3 ad=0.26p pd=1.52u as=0.2675p ps=1.535u w=1u l=0.28u
X21 VDD.t3 A.t4 a_172_68# VNW.t3 pfet_03v3 ad=0.3588p pd=1.9u as=0.3588p ps=1.9u w=1.38u l=0.28u
X22 Y.t18 a_172_68# VSS.t4 VPW.t12 nfet_03v3 ad=0.26p pd=1.52u as=0.26p ps=1.52u w=1u l=0.28u
X23 Y.t1 a_172_68# VDD.t14 VNW.t14 pfet_03v3 ad=0.3588p pd=1.9u as=0.3588p ps=1.9u w=1.38u l=0.28u
X24 a_172_68# A.t1 VSS.t1 VPW.t2 nfet_03v3 ad=0.26p pd=1.52u as=0.26p ps=1.52u w=1u l=0.28u
X25 Y.t7 a_172_68# VDD.t6 VNW.t6 pfet_03v3 ad=0.3588p pd=1.9u as=0.3588p ps=1.9u w=1.38u l=0.28u
X26 VDD.t9 a_172_68# Y.t9 VNW.t9 pfet_03v3 ad=0.3588p pd=1.9u as=0.3588p ps=1.9u w=1.38u l=0.28u
X27 Y.t12 a_172_68# VSS.t13 VPW.t6 nfet_03v3 ad=0.26p pd=1.52u as=0.26p ps=1.52u w=1u l=0.28u
X28 a_172_68# A.t7 VDD.t2 VNW.t0 pfet_03v3 ad=0.3588p pd=1.9u as=0.6072p ps=3.64u w=1.38u l=0.28u
X29 VDD.t11 a_172_68# Y.t23 VNW.t11 pfet_03v3 ad=0.3588p pd=1.9u as=0.36915p ps=1.915u w=1.38u l=0.28u
X30 VSS.t0 A.t2 a_172_68# VPW.t1 nfet_03v3 ad=0.26p pd=1.52u as=0.26p ps=1.52u w=1u l=0.28u
X31 Y.t16 a_172_68# VSS.t9 VPW.t10 nfet_03v3 ad=0.2675p pd=1.535u as=0.26p ps=1.52u w=1u l=0.28u
R0 VSS.n14 VSS.t2 8.05393
R1 VSS.n12 VSS.n1 6.38854
R2 VSS.n10 VSS.n3 6.38659
R3 VSS.n11 VSS.n2 6.38659
R4 VSS.n13 VSS.n0 6.38659
R5 VSS.n7 VSS.t14 5.23393
R6 VSS.n7 VSS.n6 3.35593
R7 VSS.n8 VSS.n5 3.35593
R8 VSS.n9 VSS.n4 3.35593
R9 VSS.n6 VSS.t8 1.6385
R10 VSS.n6 VSS.t12 1.6385
R11 VSS.n5 VSS.t4 1.6385
R12 VSS.n5 VSS.t10 1.6385
R13 VSS.n4 VSS.t9 1.6385
R14 VSS.n4 VSS.t6 1.6385
R15 VSS.n3 VSS.t15 1.6385
R16 VSS.n3 VSS.t7 1.6385
R17 VSS.n2 VSS.t13 1.6385
R18 VSS.n2 VSS.t5 1.6385
R19 VSS.n1 VSS.t11 1.6385
R20 VSS.n1 VSS.t3 1.6385
R21 VSS.n0 VSS.t1 1.6385
R22 VSS.n0 VSS.t0 1.6385
R23 VSS.n9 VSS.n8 0.24275
R24 VSS.n8 VSS.n7 0.2405
R25 VSS.n10 VSS.n9 0.2405
R26 VSS.n11 VSS.n10 0.2405
R27 VSS.n12 VSS.n11 0.2405
R28 VSS.n13 VSS.n12 0.2405
R29 VSS.n14 VSS.n13 0.2405
R30 VSS VSS.n14 0.0485
R31 Y.n8 Y.n6 6.92659
R32 Y.n16 Y.n15 6.44528
R33 Y.n17 Y.n13 6.44528
R34 Y.n18 Y.n11 6.44528
R35 Y.n9 Y.n5 6.3005
R36 Y.n8 Y.n7 6.3005
R37 Y.n3 Y.n2 3.34789
R38 Y.n16 Y.n14 2.89985
R39 Y.n17 Y.n12 2.89985
R40 Y.n18 Y.n10 2.89985
R41 Y.n4 Y.n0 2.7218
R42 Y.n3 Y.n1 2.7218
R43 Y.n11 Y.t16 1.733
R44 Y.n15 Y.t21 1.6385
R45 Y.n15 Y.t20 1.6385
R46 Y.n13 Y.t19 1.6385
R47 Y.n13 Y.t18 1.6385
R48 Y.n11 Y.t17 1.6385
R49 Y.n6 Y.t11 1.6385
R50 Y.n6 Y.t10 1.6385
R51 Y.n7 Y.t13 1.6385
R52 Y.n7 Y.t12 1.6385
R53 Y.n5 Y.t15 1.6385
R54 Y.n5 Y.t14 1.6385
R55 Y.n10 Y.t0 1.39543
R56 Y.n14 Y.t2 1.31934
R57 Y.n14 Y.t1 1.31934
R58 Y.n12 Y.t6 1.31934
R59 Y.n12 Y.t5 1.31934
R60 Y.n10 Y.t23 1.31934
R61 Y.n0 Y.t9 1.31934
R62 Y.n0 Y.t22 1.31934
R63 Y.n1 Y.t3 1.31934
R64 Y.n1 Y.t7 1.31934
R65 Y.n2 Y.t8 1.31934
R66 Y.n2 Y.t4 1.31934
R67 Y.n9 Y.n8 0.626587
R68 Y.n4 Y.n3 0.626587
R69 Y.n19 Y.n18 0.288322
R70 Y.n17 Y.n16 0.285649
R71 Y.n18 Y.n17 0.285649
R72 Y.n19 Y.n4 0.106152
R73 Y.n19 Y.n9 0.0787609
R74 Y Y.n19 0.020995
R75 VDD.n14 VDD.t2 6.67195
R76 VDD.n13 VDD.n0 5.3805
R77 VDD.n10 VDD.n3 5.37854
R78 VDD.n12 VDD.n1 5.37659
R79 VDD.n11 VDD.n2 5.37659
R80 VDD.n7 VDD.t15 3.56854
R81 VDD.n9 VDD.n4 2.0097
R82 VDD.n8 VDD.n5 2.0097
R83 VDD.n7 VDD.n6 2.0097
R84 VDD.n0 VDD.t0 1.31934
R85 VDD.n0 VDD.t1 1.31934
R86 VDD.n1 VDD.t4 1.31934
R87 VDD.n1 VDD.t3 1.31934
R88 VDD.n2 VDD.t6 1.31934
R89 VDD.n2 VDD.t5 1.31934
R90 VDD.n3 VDD.t8 1.31934
R91 VDD.n3 VDD.t7 1.31934
R92 VDD.n4 VDD.t10 1.31934
R93 VDD.n4 VDD.t9 1.31934
R94 VDD.n5 VDD.t12 1.31934
R95 VDD.n5 VDD.t11 1.31934
R96 VDD.n6 VDD.t14 1.31934
R97 VDD.n6 VDD.t13 1.31934
R98 VDD.n9 VDD.n8 0.24275
R99 VDD.n8 VDD.n7 0.2405
R100 VDD.n10 VDD.n9 0.2405
R101 VDD.n11 VDD.n10 0.2405
R102 VDD.n12 VDD.n11 0.2405
R103 VDD.n13 VDD.n12 0.2405
R104 VDD.n14 VDD.n13 0.2405
R105 VDD VDD.n14 0.0485
R106 A.n0 A.t4 22.813
R107 A.n1 A.t5 22.813
R108 A.n3 A.t6 22.813
R109 A.n2 A.t7 22.813
R110 A.n0 A.t0 19.0326
R111 A.n1 A.t1 19.0326
R112 A.n3 A.t2 19.0326
R113 A.n2 A.t3 19.0326
R114 A.n1 A.n0 13.1241
R115 A.n3 A.n2 13.1241
R116 A.n4 A.n1 7.54657
R117 A.n4 A.n3 5.57803
R118 A A.n4 1.8402
R119 VNW.t10 VNW.t11 315.892
R120 VNW.t14 VNW.t15 310.079
R121 VNW.t13 VNW.t14 310.079
R122 VNW.t12 VNW.t13 310.079
R123 VNW.t11 VNW.t12 310.079
R124 VNW.t9 VNW.t10 310.079
R125 VNW.t8 VNW.t9 310.079
R126 VNW.t7 VNW.t8 310.079
R127 VNW.t6 VNW.t7 310.079
R128 VNW.t5 VNW.t6 310.079
R129 VNW.t4 VNW.t5 310.079
R130 VNW.t3 VNW.t4 310.079
R131 VNW.t2 VNW.t3 310.079
R132 VNW.t1 VNW.t2 310.079
R133 VNW.t0 VNW.t1 310.079
R134 VNW VNW.t0 259.69
R135 VPW.t10 VPW.t11 1203.98
R136 VPW.t14 VPW.t15 1181.82
R137 VPW.t13 VPW.t14 1181.82
R138 VPW.t12 VPW.t13 1181.82
R139 VPW.t11 VPW.t12 1181.82
R140 VPW.t9 VPW.t10 1181.82
R141 VPW.t8 VPW.t9 1181.82
R142 VPW.t7 VPW.t8 1181.82
R143 VPW.t6 VPW.t7 1181.82
R144 VPW.t5 VPW.t6 1181.82
R145 VPW.t4 VPW.t5 1181.82
R146 VPW.t3 VPW.t4 1181.82
R147 VPW.t2 VPW.t3 1181.82
R148 VPW.t1 VPW.t2 1181.82
R149 VPW.t0 VPW.t1 1181.82
R150 VPW VPW.t0 989.774
C0 VDD VSS 0.04742f
C1 A a_172_68# 1.21975f
C2 a_172_68# Y 1.50559f
C3 A VNW 0.3485f
C4 VNW Y 0.15681f
C5 a_172_68# VSS 0.5142f
C6 a_172_68# VDD 0.83471f
C7 VNW VSS 0.00829f
C8 VNW VDD 0.4475f
C9 VNW a_172_68# 1.09919f
C10 A Y 0.00132f
C11 A VSS 0.09127f
C12 Y VSS 0.8431f
C13 A VDD 0.10197f
C14 Y VDD 1.75477f
C15 VSS VPW 0.9159f
C16 Y VPW 0.0842f
C17 VDD VPW 0.64568f
C18 A VPW 0.85469f
C19 VNW VPW 4.71366f
C20 a_172_68# VPW 1.3217f
C21 VNW.t15 VPW 0.29046f
C22 VNW.t14 VPW 0.11092f
C23 VNW.t13 VPW 0.11092f
C24 VNW.t12 VPW 0.11092f
C25 VNW.t11 VPW 0.11196f
C26 VNW.t10 VPW 0.11196f
C27 VNW.t9 VPW 0.11092f
C28 VNW.t8 VPW 0.11092f
C29 VNW.t7 VPW 0.11092f
C30 VNW.t6 VPW 0.11092f
C31 VNW.t5 VPW 0.11092f
C32 VNW.t4 VPW 0.11092f
C33 VNW.t3 VPW 0.11092f
C34 VNW.t2 VPW 0.11092f
C35 VNW.t1 VPW 0.11092f
C36 VNW.t0 VPW 0.1019f
C37 A.t5 VPW 0.08635f
C38 A.t1 VPW 0.06137f
C39 A.t4 VPW 0.08635f
C40 A.t0 VPW 0.06137f
C41 A.n0 VPW 0.15802f
C42 A.n1 VPW 0.17163f
C43 A.t6 VPW 0.08635f
C44 A.t2 VPW 0.06137f
C45 A.t7 VPW 0.08635f
C46 A.t3 VPW 0.06137f
C47 A.n2 VPW 0.16785f
C48 A.n3 VPW 0.16256f
C49 A.n4 VPW 0.10426f
C50 VDD.t2 VPW 0.09518f
C51 VDD.t0 VPW 0.03248f
C52 VDD.t1 VPW 0.03248f
C53 VDD.n0 VPW 0.06584f
C54 VDD.t4 VPW 0.03248f
C55 VDD.t3 VPW 0.03248f
C56 VDD.n1 VPW 0.06582f
C57 VDD.t6 VPW 0.03248f
C58 VDD.t5 VPW 0.03248f
C59 VDD.n2 VPW 0.06582f
C60 VDD.t8 VPW 0.03248f
C61 VDD.t7 VPW 0.03248f
C62 VDD.n3 VPW 0.06583f
C63 VDD.t10 VPW 0.03248f
C64 VDD.t9 VPW 0.03248f
C65 VDD.n4 VPW 0.0707f
C66 VDD.t12 VPW 0.03248f
C67 VDD.t11 VPW 0.03248f
C68 VDD.n5 VPW 0.0707f
C69 VDD.t14 VPW 0.03248f
C70 VDD.t13 VPW 0.03248f
C71 VDD.n6 VPW 0.0707f
C72 VDD.t15 VPW 0.18635f
C73 VDD.n7 VPW 0.52162f
C74 VDD.n8 VPW 0.22534f
C75 VDD.n9 VPW 0.22534f
C76 VDD.n10 VPW 0.20857f
C77 VDD.n11 VPW 0.20837f
C78 VDD.n12 VPW 0.20837f
C79 VDD.n13 VPW 0.20856f
C80 VDD.n14 VPW 0.15113f
C81 Y.t9 VPW 0.05656f
C82 Y.t22 VPW 0.05656f
C83 Y.n0 VPW 0.11539f
C84 Y.t3 VPW 0.05656f
C85 Y.t7 VPW 0.05656f
C86 Y.n1 VPW 0.11539f
C87 Y.t8 VPW 0.05656f
C88 Y.t4 VPW 0.05656f
C89 Y.n2 VPW 0.13897f
C90 Y.n3 VPW 0.27827f
C91 Y.n4 VPW 0.13588f
C92 Y.t15 VPW 0.04099f
C93 Y.t14 VPW 0.04099f
C94 Y.n5 VPW 0.08197f
C95 Y.t11 VPW 0.04099f
C96 Y.t10 VPW 0.04099f
C97 Y.n6 VPW 0.08725f
C98 Y.t13 VPW 0.04099f
C99 Y.t12 VPW 0.04099f
C100 Y.n7 VPW 0.08197f
C101 Y.n8 VPW 0.16115f
C102 Y.n9 VPW 0.06563f
C103 Y.t23 VPW 0.05656f
C104 Y.t0 VPW 0.05983f
C105 Y.n10 VPW 0.12367f
C106 Y.t17 VPW 0.04099f
C107 Y.t16 VPW 0.04335f
C108 Y.n11 VPW 0.08492f
C109 Y.t6 VPW 0.05656f
C110 Y.t5 VPW 0.05656f
C111 Y.n12 VPW 0.12041f
C112 Y.t19 VPW 0.04099f
C113 Y.t18 VPW 0.04099f
C114 Y.n13 VPW 0.08255f
C115 Y.t2 VPW 0.05656f
C116 Y.t1 VPW 0.05656f
C117 Y.n14 VPW 0.12041f
C118 Y.t21 VPW 0.04099f
C119 Y.t20 VPW 0.04099f
C120 Y.n15 VPW 0.08255f
C121 Y.n16 VPW 0.27525f
C122 Y.n17 VPW 0.38431f
C123 Y.n18 VPW 0.3855f
C124 Y.n19 VPW 0.15476f
C125 VSS.t2 VPW 0.03822f
C126 VSS.t1 VPW 0.01314f
C127 VSS.t0 VPW 0.01314f
C128 VSS.n0 VPW 0.02637f
C129 VSS.t11 VPW 0.01314f
C130 VSS.t3 VPW 0.01314f
C131 VSS.n1 VPW 0.02637f
C132 VSS.t13 VPW 0.01314f
C133 VSS.t5 VPW 0.01314f
C134 VSS.n2 VPW 0.02637f
C135 VSS.t15 VPW 0.01314f
C136 VSS.t7 VPW 0.01314f
C137 VSS.n3 VPW 0.02637f
C138 VSS.t9 VPW 0.01314f
C139 VSS.t6 VPW 0.01314f
C140 VSS.n4 VPW 0.02732f
C141 VSS.t4 VPW 0.01314f
C142 VSS.t10 VPW 0.01314f
C143 VSS.n5 VPW 0.02732f
C144 VSS.t8 VPW 0.01314f
C145 VSS.t12 VPW 0.01314f
C146 VSS.n6 VPW 0.02732f
C147 VSS.t14 VPW 0.07886f
C148 VSS.n7 VPW 0.26406f
C149 VSS.n8 VPW 0.11965f
C150 VSS.n9 VPW 0.11965f
C151 VSS.n10 VPW 0.10644f
C152 VSS.n11 VPW 0.10644f
C153 VSS.n12 VPW 0.10644f
C154 VSS.n13 VPW 0.10644f
C155 VSS.n14 VPW 0.077f
.ends

* NGSPICE file created from gf180mcu_as_sc_mcu7t3v3__buff_16.ext - technology: gf180mcuD

.subckt gf180mcu_as_sc_mcu7t3v3__buff_16 VDD VNW VPW VSS A Y
X0 VDD.t19 a_172_68# Y.t9 VNW.t19 pfet_03v3 ad=0.8073p pd=3.93u as=0.3588p ps=1.9u w=1.38u l=0.28u
X1 VSS.t12 a_172_68# Y.t26 VPW.t15 nfet_03v3 ad=0.26p pd=1.52u as=0.26p ps=1.52u w=1u l=0.28u
X2 VSS.t11 a_172_68# Y.t16 VPW.t5 nfet_03v3 ad=0.26p pd=1.52u as=0.26p ps=1.52u w=1u l=0.28u
X3 VDD.t2 A.t6 a_172_68# VNW.t1 pfet_03v3 ad=0.3588p pd=1.9u as=0.3588p ps=1.9u w=1.38u l=0.28u
X4 Y.t1 a_172_68# VDD.t4 VNW.t4 pfet_03v3 ad=0.3588p pd=1.9u as=0.3588p ps=1.9u w=1.38u l=0.28u
X5 Y.t11 a_172_68# VDD.t12 VNW.t12 pfet_03v3 ad=0.3588p pd=1.9u as=0.3588p ps=1.9u w=1.38u l=0.28u
X6 VDD.t15 a_172_68# Y.t2 VNW.t15 pfet_03v3 ad=0.3588p pd=1.9u as=0.3588p ps=1.9u w=1.38u l=0.28u
X7 a_172_68# A.t3 VSS.t0 VPW.t0 nfet_03v3 ad=0.26p pd=1.52u as=0.44p ps=2.88u w=1u l=0.28u
X8 VSS.t10 a_172_68# Y.t20 VPW.t9 nfet_03v3 ad=0.26p pd=1.52u as=0.26p ps=1.52u w=1u l=0.28u
X9 VDD.t7 a_172_68# Y.t7 VNW.t7 pfet_03v3 ad=0.3588p pd=1.9u as=0.3588p ps=1.9u w=1.38u l=0.28u
X10 Y.t8 a_172_68# VDD.t10 VNW.t10 pfet_03v3 ad=0.36915p pd=1.915u as=0.3588p ps=1.9u w=1.38u l=0.28u
X11 VDD.t13 a_172_68# Y.t3 VNW.t13 pfet_03v3 ad=0.3588p pd=1.9u as=0.3588p ps=1.9u w=1.38u l=0.28u
X12 Y.t25 a_172_68# VSS.t18 VPW.t14 nfet_03v3 ad=0.26p pd=1.52u as=0.26p ps=1.52u w=1u l=0.28u
X13 Y.t6 a_172_68# VDD.t16 VNW.t16 pfet_03v3 ad=0.3588p pd=1.9u as=0.3588p ps=1.9u w=1.38u l=0.28u
X14 Y.t15 a_172_68# VSS.t7 VPW.t4 nfet_03v3 ad=0.26p pd=1.52u as=0.26p ps=1.52u w=1u l=0.28u
X15 Y.t14 a_172_68# VDD.t8 VNW.t8 pfet_03v3 ad=0.3588p pd=1.9u as=0.3588p ps=1.9u w=1.38u l=0.28u
X16 Y.t19 a_172_68# VSS.t6 VPW.t8 nfet_03v3 ad=0.26p pd=1.52u as=0.26p ps=1.52u w=1u l=0.28u
X17 Y.t29 a_172_68# VSS.t17 VPW.t18 nfet_03v3 ad=0.26p pd=1.52u as=0.26p ps=1.52u w=1u l=0.28u
X18 VSS.t13 a_172_68# Y.t30 VPW.t19 nfet_03v3 ad=0.585p pd=3.17u as=0.26p ps=1.52u w=1u l=0.28u
X19 a_172_68# A.t5 VDD.t3 VNW.t2 pfet_03v3 ad=0.3588p pd=1.9u as=0.3588p ps=1.9u w=1.38u l=0.28u
X20 VSS.t16 a_172_68# Y.t24 VPW.t13 nfet_03v3 ad=0.26p pd=1.52u as=0.26p ps=1.52u w=1u l=0.28u
X21 VDD.t5 a_172_68# Y.t12 VNW.t5 pfet_03v3 ad=0.3588p pd=1.9u as=0.3588p ps=1.9u w=1.38u l=0.28u
X22 VSS.t3 A.t0 a_172_68# VPW.t3 nfet_03v3 ad=0.26p pd=1.52u as=0.26p ps=1.52u w=1u l=0.28u
X23 VSS.t9 a_172_68# Y.t18 VPW.t7 nfet_03v3 ad=0.26p pd=1.52u as=0.26p ps=1.52u w=1u l=0.28u
X24 VSS.t8 a_172_68# Y.t22 VPW.t11 nfet_03v3 ad=0.26p pd=1.52u as=0.2675p ps=1.535u w=1u l=0.28u
X25 VSS.t15 a_172_68# Y.t28 VPW.t17 nfet_03v3 ad=0.26p pd=1.52u as=0.26p ps=1.52u w=1u l=0.28u
X26 VDD.t0 A.t4 a_172_68# VNW.t3 pfet_03v3 ad=0.3588p pd=1.9u as=0.3588p ps=1.9u w=1.38u l=0.28u
X27 Y.t23 a_172_68# VSS.t14 VPW.t12 nfet_03v3 ad=0.26p pd=1.52u as=0.26p ps=1.52u w=1u l=0.28u
X28 Y.t5 a_172_68# VDD.t14 VNW.t14 pfet_03v3 ad=0.3588p pd=1.9u as=0.3588p ps=1.9u w=1.38u l=0.28u
X29 VDD.t17 a_172_68# Y.t0 VNW.t17 pfet_03v3 ad=0.3588p pd=1.9u as=0.3588p ps=1.9u w=1.38u l=0.28u
X30 a_172_68# A.t1 VSS.t1 VPW.t2 nfet_03v3 ad=0.26p pd=1.52u as=0.26p ps=1.52u w=1u l=0.28u
X31 Y.t31 a_172_68# VDD.t6 VNW.t6 pfet_03v3 ad=0.3588p pd=1.9u as=0.3588p ps=1.9u w=1.38u l=0.28u
X32 VDD.t9 a_172_68# Y.t13 VNW.t9 pfet_03v3 ad=0.3588p pd=1.9u as=0.3588p ps=1.9u w=1.38u l=0.28u
X33 Y.t17 a_172_68# VSS.t5 VPW.t6 nfet_03v3 ad=0.26p pd=1.52u as=0.26p ps=1.52u w=1u l=0.28u
X34 Y.t4 a_172_68# VDD.t18 VNW.t18 pfet_03v3 ad=0.3588p pd=1.9u as=0.3588p ps=1.9u w=1.38u l=0.28u
X35 Y.t27 a_172_68# VSS.t19 VPW.t16 nfet_03v3 ad=0.26p pd=1.52u as=0.26p ps=1.52u w=1u l=0.28u
X36 a_172_68# A.t7 VDD.t1 VNW.t0 pfet_03v3 ad=0.3588p pd=1.9u as=0.6072p ps=3.64u w=1.38u l=0.28u
X37 VDD.t11 a_172_68# Y.t10 VNW.t11 pfet_03v3 ad=0.3588p pd=1.9u as=0.36915p ps=1.915u w=1.38u l=0.28u
X38 VSS.t2 A.t2 a_172_68# VPW.t1 nfet_03v3 ad=0.26p pd=1.52u as=0.26p ps=1.52u w=1u l=0.28u
X39 Y.t21 a_172_68# VSS.t4 VPW.t10 nfet_03v3 ad=0.2675p pd=1.535u as=0.26p ps=1.52u w=1u l=0.28u
R0 VSS.n18 VSS.t0 8.05393
R1 VSS.n16 VSS.n1 6.38854
R2 VSS.n14 VSS.n3 6.38659
R3 VSS.n15 VSS.n2 6.38659
R4 VSS.n17 VSS.n0 6.38659
R5 VSS.n9 VSS.t13 5.23393
R6 VSS.n9 VSS.n8 3.35593
R7 VSS.n10 VSS.n7 3.35593
R8 VSS.n11 VSS.n6 3.35593
R9 VSS.n12 VSS.n5 3.35593
R10 VSS.n13 VSS.n4 3.35593
R11 VSS.n8 VSS.t17 1.6385
R12 VSS.n8 VSS.t15 1.6385
R13 VSS.n7 VSS.t19 1.6385
R14 VSS.n7 VSS.t12 1.6385
R15 VSS.n6 VSS.t18 1.6385
R16 VSS.n6 VSS.t16 1.6385
R17 VSS.n5 VSS.t14 1.6385
R18 VSS.n5 VSS.t8 1.6385
R19 VSS.n4 VSS.t4 1.6385
R20 VSS.n4 VSS.t10 1.6385
R21 VSS.n3 VSS.t6 1.6385
R22 VSS.n3 VSS.t9 1.6385
R23 VSS.n2 VSS.t5 1.6385
R24 VSS.n2 VSS.t11 1.6385
R25 VSS.n1 VSS.t7 1.6385
R26 VSS.n1 VSS.t3 1.6385
R27 VSS.n0 VSS.t1 1.6385
R28 VSS.n0 VSS.t2 1.6385
R29 VSS.n13 VSS.n12 0.24275
R30 VSS.n10 VSS.n9 0.2405
R31 VSS.n11 VSS.n10 0.2405
R32 VSS.n12 VSS.n11 0.2405
R33 VSS.n14 VSS.n13 0.2405
R34 VSS.n15 VSS.n14 0.2405
R35 VSS.n16 VSS.n15 0.2405
R36 VSS.n17 VSS.n16 0.2405
R37 VSS.n18 VSS.n17 0.2405
R38 VSS VSS.n18 0.0485
R39 Y.n8 Y.n6 6.92659
R40 Y.n20 Y.n19 6.44528
R41 Y.n21 Y.n17 6.44528
R42 Y.n22 Y.n15 6.44528
R43 Y.n23 Y.n13 6.44528
R44 Y.n24 Y.n11 6.44528
R45 Y.n9 Y.n5 6.3005
R46 Y.n8 Y.n7 6.3005
R47 Y.n3 Y.n2 3.34789
R48 Y.n20 Y.n18 2.89985
R49 Y.n21 Y.n16 2.89985
R50 Y.n22 Y.n14 2.89985
R51 Y.n23 Y.n12 2.89985
R52 Y.n24 Y.n10 2.89985
R53 Y.n4 Y.n0 2.7218
R54 Y.n3 Y.n1 2.7218
R55 Y.n11 Y.t21 1.733
R56 Y.n19 Y.t30 1.6385
R57 Y.n19 Y.t29 1.6385
R58 Y.n17 Y.t28 1.6385
R59 Y.n17 Y.t27 1.6385
R60 Y.n15 Y.t26 1.6385
R61 Y.n15 Y.t25 1.6385
R62 Y.n13 Y.t24 1.6385
R63 Y.n13 Y.t23 1.6385
R64 Y.n11 Y.t22 1.6385
R65 Y.n6 Y.t16 1.6385
R66 Y.n6 Y.t15 1.6385
R67 Y.n7 Y.t18 1.6385
R68 Y.n7 Y.t17 1.6385
R69 Y.n5 Y.t20 1.6385
R70 Y.n5 Y.t19 1.6385
R71 Y.n10 Y.t8 1.39543
R72 Y.n18 Y.t9 1.31934
R73 Y.n18 Y.t4 1.31934
R74 Y.n16 Y.t0 1.31934
R75 Y.n16 Y.t6 1.31934
R76 Y.n14 Y.t2 1.31934
R77 Y.n14 Y.t5 1.31934
R78 Y.n12 Y.t3 1.31934
R79 Y.n12 Y.t11 1.31934
R80 Y.n10 Y.t10 1.31934
R81 Y.n0 Y.t13 1.31934
R82 Y.n0 Y.t14 1.31934
R83 Y.n1 Y.t7 1.31934
R84 Y.n1 Y.t31 1.31934
R85 Y.n2 Y.t12 1.31934
R86 Y.n2 Y.t1 1.31934
R87 Y.n9 Y.n8 0.626587
R88 Y.n4 Y.n3 0.626587
R89 Y.n25 Y.n24 0.288322
R90 Y.n21 Y.n20 0.285649
R91 Y.n22 Y.n21 0.285649
R92 Y.n23 Y.n22 0.285649
R93 Y.n24 Y.n23 0.285649
R94 Y.n25 Y.n4 0.106152
R95 Y.n25 Y.n9 0.0787609
R96 Y Y.n25 0.020995
R97 VDD.n18 VDD.t1 6.67195
R98 VDD.n17 VDD.n0 5.3805
R99 VDD.n14 VDD.n3 5.37854
R100 VDD.n16 VDD.n1 5.37659
R101 VDD.n15 VDD.n2 5.37659
R102 VDD.n9 VDD.t19 3.56854
R103 VDD.n13 VDD.n4 2.0097
R104 VDD.n12 VDD.n5 2.0097
R105 VDD.n11 VDD.n6 2.0097
R106 VDD.n10 VDD.n7 2.0097
R107 VDD.n9 VDD.n8 2.0097
R108 VDD.n0 VDD.t3 1.31934
R109 VDD.n0 VDD.t2 1.31934
R110 VDD.n1 VDD.t4 1.31934
R111 VDD.n1 VDD.t0 1.31934
R112 VDD.n2 VDD.t6 1.31934
R113 VDD.n2 VDD.t5 1.31934
R114 VDD.n3 VDD.t8 1.31934
R115 VDD.n3 VDD.t7 1.31934
R116 VDD.n4 VDD.t10 1.31934
R117 VDD.n4 VDD.t9 1.31934
R118 VDD.n5 VDD.t12 1.31934
R119 VDD.n5 VDD.t11 1.31934
R120 VDD.n6 VDD.t14 1.31934
R121 VDD.n6 VDD.t13 1.31934
R122 VDD.n7 VDD.t16 1.31934
R123 VDD.n7 VDD.t15 1.31934
R124 VDD.n8 VDD.t18 1.31934
R125 VDD.n8 VDD.t17 1.31934
R126 VDD.n13 VDD.n12 0.24275
R127 VDD.n10 VDD.n9 0.2405
R128 VDD.n11 VDD.n10 0.2405
R129 VDD.n12 VDD.n11 0.2405
R130 VDD.n14 VDD.n13 0.2405
R131 VDD.n15 VDD.n14 0.2405
R132 VDD.n16 VDD.n15 0.2405
R133 VDD.n17 VDD.n16 0.2405
R134 VDD.n18 VDD.n17 0.2405
R135 VDD VDD.n18 0.0485
R136 A.n0 A.t4 22.813
R137 A.n1 A.t5 22.813
R138 A.n3 A.t6 22.813
R139 A.n2 A.t7 22.813
R140 A.n0 A.t0 19.0326
R141 A.n1 A.t1 19.0326
R142 A.n3 A.t2 19.0326
R143 A.n2 A.t3 19.0326
R144 A.n1 A.n0 13.1241
R145 A.n3 A.n2 13.1241
R146 A.n4 A.n1 7.54657
R147 A.n4 A.n3 5.57803
R148 A A.n4 1.8402
R149 VNW.t10 VNW.t11 315.892
R150 VNW.t18 VNW.t19 310.079
R151 VNW.t17 VNW.t18 310.079
R152 VNW.t16 VNW.t17 310.079
R153 VNW.t15 VNW.t16 310.079
R154 VNW.t14 VNW.t15 310.079
R155 VNW.t13 VNW.t14 310.079
R156 VNW.t12 VNW.t13 310.079
R157 VNW.t11 VNW.t12 310.079
R158 VNW.t9 VNW.t10 310.079
R159 VNW.t8 VNW.t9 310.079
R160 VNW.t7 VNW.t8 310.079
R161 VNW.t6 VNW.t7 310.079
R162 VNW.t5 VNW.t6 310.079
R163 VNW.t4 VNW.t5 310.079
R164 VNW.t3 VNW.t4 310.079
R165 VNW.t2 VNW.t3 310.079
R166 VNW.t1 VNW.t2 310.079
R167 VNW.t0 VNW.t1 310.079
R168 VNW VNW.t0 259.69
R169 VPW.t10 VPW.t11 1203.98
R170 VPW.t18 VPW.t19 1181.82
R171 VPW.t17 VPW.t18 1181.82
R172 VPW.t16 VPW.t17 1181.82
R173 VPW.t15 VPW.t16 1181.82
R174 VPW.t14 VPW.t15 1181.82
R175 VPW.t13 VPW.t14 1181.82
R176 VPW.t12 VPW.t13 1181.82
R177 VPW.t11 VPW.t12 1181.82
R178 VPW.t9 VPW.t10 1181.82
R179 VPW.t8 VPW.t9 1181.82
R180 VPW.t7 VPW.t8 1181.82
R181 VPW.t6 VPW.t7 1181.82
R182 VPW.t5 VPW.t6 1181.82
R183 VPW.t4 VPW.t5 1181.82
R184 VPW.t3 VPW.t4 1181.82
R185 VPW.t2 VPW.t3 1181.82
R186 VPW.t1 VPW.t2 1181.82
R187 VPW.t0 VPW.t1 1181.82
R188 VPW VPW.t0 989.774
C0 VSS A 0.09127f
C1 VSS a_172_68# 0.61675f
C2 VNW A 0.3485f
C3 VNW a_172_68# 1.4479f
C4 Y VDD 2.42355f
C5 VSS VNW 0.00695f
C6 Y A 0.00132f
C7 Y a_172_68# 1.72f
C8 VDD A 0.10197f
C9 VDD a_172_68# 0.94488f
C10 VSS Y 1.19848f
C11 Y VNW 0.21164f
C12 a_172_68# A 1.21975f
C13 VSS VDD 0.03795f
C14 VNW VDD 0.53821f
C15 VSS VPW 1.08059f
C16 Y VPW 0.10865f
C17 VDD VPW 0.75696f
C18 A VPW 0.85469f
C19 VNW VPW 5.58537f
C20 a_172_68# VPW 1.74826f
C21 VNW.t19 VPW 0.24505f
C22 VNW.t18 VPW 0.11566f
C23 VNW.t17 VPW 0.11566f
C24 VNW.t16 VPW 0.11566f
C25 VNW.t15 VPW 0.11566f
C26 VNW.t14 VPW 0.11566f
C27 VNW.t13 VPW 0.11566f
C28 VNW.t12 VPW 0.11566f
C29 VNW.t11 VPW 0.11674f
C30 VNW.t10 VPW 0.11674f
C31 VNW.t9 VPW 0.11566f
C32 VNW.t8 VPW 0.11566f
C33 VNW.t7 VPW 0.11566f
C34 VNW.t6 VPW 0.11566f
C35 VNW.t5 VPW 0.11566f
C36 VNW.t4 VPW 0.11566f
C37 VNW.t3 VPW 0.11566f
C38 VNW.t2 VPW 0.11566f
C39 VNW.t1 VPW 0.11566f
C40 VNW.t0 VPW 0.10626f
C41 A.t5 VPW 0.08635f
C42 A.t1 VPW 0.06137f
C43 A.t4 VPW 0.08635f
C44 A.t0 VPW 0.06137f
C45 A.n0 VPW 0.15802f
C46 A.n1 VPW 0.17163f
C47 A.t6 VPW 0.08635f
C48 A.t2 VPW 0.06137f
C49 A.t7 VPW 0.08635f
C50 A.t3 VPW 0.06137f
C51 A.n2 VPW 0.16785f
C52 A.n3 VPW 0.16256f
C53 A.n4 VPW 0.10426f
C54 VDD.t1 VPW 0.10234f
C55 VDD.t3 VPW 0.03493f
C56 VDD.t2 VPW 0.03493f
C57 VDD.n0 VPW 0.07079f
C58 VDD.t4 VPW 0.03493f
C59 VDD.t0 VPW 0.03493f
C60 VDD.n1 VPW 0.07077f
C61 VDD.t6 VPW 0.03493f
C62 VDD.t5 VPW 0.03493f
C63 VDD.n2 VPW 0.07077f
C64 VDD.t8 VPW 0.03493f
C65 VDD.t7 VPW 0.03493f
C66 VDD.n3 VPW 0.07079f
C67 VDD.t10 VPW 0.03493f
C68 VDD.t9 VPW 0.03493f
C69 VDD.n4 VPW 0.07602f
C70 VDD.t12 VPW 0.03493f
C71 VDD.t11 VPW 0.03493f
C72 VDD.n5 VPW 0.07602f
C73 VDD.t14 VPW 0.03493f
C74 VDD.t13 VPW 0.03493f
C75 VDD.n6 VPW 0.07602f
C76 VDD.t16 VPW 0.03493f
C77 VDD.t15 VPW 0.03493f
C78 VDD.n7 VPW 0.07602f
C79 VDD.t18 VPW 0.03493f
C80 VDD.t17 VPW 0.03493f
C81 VDD.n8 VPW 0.07602f
C82 VDD.t19 VPW 0.12948f
C83 VDD.n9 VPW 0.47756f
C84 VDD.n10 VPW 0.24142f
C85 VDD.n11 VPW 0.24142f
C86 VDD.n12 VPW 0.24229f
C87 VDD.n13 VPW 0.24229f
C88 VDD.n14 VPW 0.22426f
C89 VDD.n15 VPW 0.22405f
C90 VDD.n16 VPW 0.22405f
C91 VDD.n17 VPW 0.22426f
C92 VDD.n18 VPW 0.1625f
C93 Y.t13 VPW 0.05393f
C94 Y.t14 VPW 0.05393f
C95 Y.n0 VPW 0.11001f
C96 Y.t7 VPW 0.05393f
C97 Y.t31 VPW 0.05393f
C98 Y.n1 VPW 0.11001f
C99 Y.t12 VPW 0.05393f
C100 Y.t1 VPW 0.05393f
C101 Y.n2 VPW 0.1325f
C102 Y.n3 VPW 0.26531f
C103 Y.n4 VPW 0.12955f
C104 Y.t20 VPW 0.03908f
C105 Y.t19 VPW 0.03908f
C106 Y.n5 VPW 0.07816f
C107 Y.t16 VPW 0.03908f
C108 Y.t15 VPW 0.03908f
C109 Y.n6 VPW 0.08319f
C110 Y.t18 VPW 0.03908f
C111 Y.t17 VPW 0.03908f
C112 Y.n7 VPW 0.07816f
C113 Y.n8 VPW 0.15364f
C114 Y.n9 VPW 0.06257f
C115 Y.t10 VPW 0.05393f
C116 Y.t8 VPW 0.05704f
C117 Y.n10 VPW 0.11791f
C118 Y.t22 VPW 0.03908f
C119 Y.t21 VPW 0.04133f
C120 Y.n11 VPW 0.08096f
C121 Y.t3 VPW 0.05393f
C122 Y.t11 VPW 0.05393f
C123 Y.n12 VPW 0.1148f
C124 Y.t24 VPW 0.03908f
C125 Y.t23 VPW 0.03908f
C126 Y.n13 VPW 0.07871f
C127 Y.t2 VPW 0.05393f
C128 Y.t5 VPW 0.05393f
C129 Y.n14 VPW 0.1148f
C130 Y.t26 VPW 0.03908f
C131 Y.t25 VPW 0.03908f
C132 Y.n15 VPW 0.07871f
C133 Y.t0 VPW 0.05393f
C134 Y.t6 VPW 0.05393f
C135 Y.n16 VPW 0.1148f
C136 Y.t28 VPW 0.03908f
C137 Y.t27 VPW 0.03908f
C138 Y.n17 VPW 0.07871f
C139 Y.t9 VPW 0.05393f
C140 Y.t4 VPW 0.05393f
C141 Y.n18 VPW 0.1148f
C142 Y.t30 VPW 0.03908f
C143 Y.t29 VPW 0.03908f
C144 Y.n19 VPW 0.07871f
C145 Y.n20 VPW 0.26243f
C146 Y.n21 VPW 0.36641f
C147 Y.n22 VPW 0.36641f
C148 Y.n23 VPW 0.36641f
C149 Y.n24 VPW 0.36755f
C150 Y.n25 VPW 0.14755f
C151 VSS.t0 VPW 0.04178f
C152 VSS.t1 VPW 0.01436f
C153 VSS.t2 VPW 0.01436f
C154 VSS.n0 VPW 0.02882f
C155 VSS.t7 VPW 0.01436f
C156 VSS.t3 VPW 0.01436f
C157 VSS.n1 VPW 0.02882f
C158 VSS.t5 VPW 0.01436f
C159 VSS.t11 VPW 0.01436f
C160 VSS.n2 VPW 0.02882f
C161 VSS.t6 VPW 0.01436f
C162 VSS.t9 VPW 0.01436f
C163 VSS.n3 VPW 0.02882f
C164 VSS.t4 VPW 0.01436f
C165 VSS.t10 VPW 0.01436f
C166 VSS.n4 VPW 0.02987f
C167 VSS.t14 VPW 0.01436f
C168 VSS.t8 VPW 0.01436f
C169 VSS.n5 VPW 0.02987f
C170 VSS.t18 VPW 0.01436f
C171 VSS.t16 VPW 0.01436f
C172 VSS.n6 VPW 0.02987f
C173 VSS.t19 VPW 0.01436f
C174 VSS.t12 VPW 0.01436f
C175 VSS.n7 VPW 0.02987f
C176 VSS.t17 VPW 0.01436f
C177 VSS.t15 VPW 0.01436f
C178 VSS.n8 VPW 0.02987f
C179 VSS.t13 VPW 0.05463f
C180 VSS.n9 VPW 0.24953f
C181 VSS.n10 VPW 0.1303f
C182 VSS.n11 VPW 0.1303f
C183 VSS.n12 VPW 0.1308f
C184 VSS.n13 VPW 0.1308f
C185 VSS.n14 VPW 0.11635f
C186 VSS.n15 VPW 0.11635f
C187 VSS.n16 VPW 0.11635f
C188 VSS.n17 VPW 0.11635f
C189 VSS.n18 VPW 0.08416f
.ends

* NGSPICE file created from gf180mcu_as_sc_mcu7t3v3__buff_2.ext - technology: gf180mcuD

.subckt gf180mcu_as_sc_mcu7t3v3__buff_2 VDD VNW VPW VSS A Y
X0 Y.t0 a_28_68# VDD.t1 VNW.t1 pfet_03v3 ad=0.3588p pd=1.9u as=0.3588p ps=1.9u w=1.38u l=0.28u
X1 VSS.t0 A.t0 a_28_68# VPW.t0 nfet_03v3 ad=0.26p pd=1.52u as=0.44p ps=2.88u w=1u l=0.28u
X2 VDD.t2 a_28_68# Y.t3 VNW.t2 pfet_03v3 ad=1.0488p pd=4.28u as=0.3588p ps=1.9u w=1.38u l=0.28u
X3 VSS.t2 a_28_68# Y.t2 VPW.t2 nfet_03v3 ad=0.76p pd=3.52u as=0.26p ps=1.52u w=1u l=0.28u
X4 VDD.t0 A.t1 a_28_68# VNW.t0 pfet_03v3 ad=0.3588p pd=1.9u as=0.6072p ps=3.64u w=1.38u l=0.28u
X5 Y.t1 a_28_68# VSS.t1 VPW.t1 nfet_03v3 ad=0.26p pd=1.52u as=0.26p ps=1.52u w=1u l=0.28u
R0 VSS.n1 VSS.n0 6.38659
R1 VSS.n1 VSS.t2 5.59455
R2 VSS.n0 VSS.t1 1.6385
R3 VSS.n0 VSS.t0 1.6385
R4 VSS VSS.n1 0.1685
R5 Y.n2 Y.n1 6.3005
R6 Y.n2 Y.n0 3.02999
R7 Y.n1 Y.t2 1.6385
R8 Y.n1 Y.t1 1.6385
R9 Y.n0 Y.t3 1.31934
R10 Y.n0 Y.t0 1.31934
R11 Y Y.n2 0.0882215
R12 VDD.n1 VDD.n0 5.28659
R13 VDD.n1 VDD.t2 3.85578
R14 VDD.n0 VDD.t1 1.31934
R15 VDD.n0 VDD.t0 1.31934
R16 VDD VDD.n1 0.1685
R17 A.n0 A.t1 25.9788
R18 A.n0 A.t0 22.3847
R19 A A.n0 8.04519
R20 VNW.t1 VNW.t2 310.079
R21 VNW.t0 VNW.t1 310.079
R22 VNW VNW.t0 259.69
R23 VPW.t1 VPW.t2 1181.82
R24 VPW.t0 VPW.t1 1181.82
R25 VPW VPW.t0 989.774
C0 a_28_68# VNW 0.19875f
C1 VNW VDD 0.11273f
C2 VSS A 0.01447f
C3 Y VNW 0.02099f
C4 a_28_68# A 0.28733f
C5 A VDD 0.01515f
C6 Y A 0.00226f
C7 VSS a_28_68# 0.18038f
C8 VSS VDD 0.03675f
C9 Y VSS 0.20001f
C10 VNW A 0.09117f
C11 a_28_68# VDD 0.20958f
C12 VSS VNW 0.00624f
C13 Y a_28_68# 0.27997f
C14 Y VDD 0.228f
C15 VSS VPW 0.33686f
C16 Y VPW 0.05411f
C17 VDD VPW 0.26139f
C18 A VPW 0.25492f
C19 VNW VPW 1.38953f
C20 a_28_68# VPW 0.28862f
C21 VNW.t2 VPW 0.19049f
C22 VNW.t1 VPW 0.08149f
C23 VNW.t0 VPW 0.07487f
C24 A.t1 VPW 0.09322f
C25 A.t0 VPW 0.06893f
C26 A.n0 VPW 0.13519f
C27 VDD.t1 VPW 0.02582f
C28 VDD.t0 VPW 0.02582f
C29 VDD.n0 VPW 0.0518f
C30 VDD.t2 VPW 0.11449f
C31 VDD.n1 VPW 0.33593f
C32 Y.t3 VPW 0.05542f
C33 Y.t0 VPW 0.05542f
C34 Y.n0 VPW 0.13734f
C35 Y.t2 VPW 0.04016f
C36 Y.t1 VPW 0.04016f
C37 Y.n1 VPW 0.08031f
C38 Y.n2 VPW 0.29895f
C39 VSS.t1 VPW 0.01564f
C40 VSS.t0 VPW 0.01564f
C41 VSS.n0 VPW 0.03139f
C42 VSS.t2 VPW 0.07248f
C43 VSS.n1 VPW 0.26226f
.ends

* NGSPICE file created from gf180mcu_as_sc_mcu7t3v3__buff_4.ext - technology: gf180mcuD

.subckt gf180mcu_as_sc_mcu7t3v3__buff_4 VDD VNW VPW VSS A Y
X0 Y.t6 a_28_68# VDD.t1 VNW.t1 pfet_03v3 ad=0.3588p pd=1.9u as=0.3588p ps=1.9u w=1.38u l=0.28u
X1 VDD.t4 a_28_68# Y.t1 VNW.t4 pfet_03v3 ad=1.1592p pd=4.44u as=0.3588p ps=1.9u w=1.38u l=0.28u
X2 VSS.t0 A.t0 a_28_68# VPW.t0 nfet_03v3 ad=0.26p pd=1.52u as=0.44p ps=2.88u w=1u l=0.28u
X3 VSS.t2 a_28_68# Y.t5 VPW.t4 nfet_03v3 ad=0.84p pd=3.68u as=0.26p ps=1.52u w=1u l=0.28u
X4 VDD.t2 a_28_68# Y.t7 VNW.t2 pfet_03v3 ad=0.3588p pd=1.9u as=0.3588p ps=1.9u w=1.38u l=0.28u
X5 Y.t4 a_28_68# VSS.t3 VPW.t3 nfet_03v3 ad=0.26p pd=1.52u as=0.26p ps=1.52u w=1u l=0.28u
X6 Y.t0 a_28_68# VDD.t3 VNW.t3 pfet_03v3 ad=0.3588p pd=1.9u as=0.3588p ps=1.9u w=1.38u l=0.28u
X7 VSS.t1 a_28_68# Y.t3 VPW.t2 nfet_03v3 ad=0.26p pd=1.52u as=0.26p ps=1.52u w=1u l=0.28u
X8 VDD.t0 A.t1 a_28_68# VNW.t0 pfet_03v3 ad=0.3588p pd=1.9u as=0.6072p ps=3.64u w=1.38u l=0.28u
X9 Y.t2 a_28_68# VSS.t4 VPW.t1 nfet_03v3 ad=0.26p pd=1.52u as=0.26p ps=1.52u w=1u l=0.28u
R0 VSS.n2 VSS.n1 6.38659
R1 VSS.n3 VSS.n0 6.38659
R2 VSS.n2 VSS.t2 5.2398
R3 VSS.n1 VSS.t3 1.6385
R4 VSS.n1 VSS.t1 1.6385
R5 VSS.n0 VSS.t4 1.6385
R6 VSS.n0 VSS.t0 1.6385
R7 VSS.n3 VSS.n2 0.2405
R8 VSS VSS.n3 0.1685
R9 Y.n7 Y.n6 6.3005
R10 Y.n3 Y.n2 6.3005
R11 Y.n5 Y.n0 2.8067
R12 Y.n4 Y.n1 2.8067
R13 Y.n2 Y.t5 1.6385
R14 Y.n2 Y.t4 1.6385
R15 Y.n6 Y.t3 1.6385
R16 Y.n6 Y.t2 1.6385
R17 Y.n1 Y.t1 1.31934
R18 Y.n1 Y.t0 1.31934
R19 Y.n0 Y.t7 1.31934
R20 Y.n0 Y.t6 1.31934
R21 Y.n5 Y.n4 0.381026
R22 Y.n7 Y.n5 0.223791
R23 Y.n4 Y.n3 0.223791
R24 Y Y.n7 0.0882215
R25 Y.n3 Y 0.0882215
R26 VDD.n3 VDD.n0 5.28659
R27 VDD.n2 VDD.n1 5.28659
R28 VDD.n2 VDD.t4 3.57833
R29 VDD.n0 VDD.t1 1.31934
R30 VDD.n0 VDD.t0 1.31934
R31 VDD.n1 VDD.t3 1.31934
R32 VDD.n1 VDD.t2 1.31934
R33 VDD.n3 VDD.n2 0.2405
R34 VDD VDD.n3 0.1685
R35 A.n0 A.t1 25.9788
R36 A.n0 A.t0 22.3847
R37 A A.n0 8.04519
R38 VNW.t3 VNW.t4 310.079
R39 VNW.t2 VNW.t3 310.079
R40 VNW.t1 VNW.t2 310.079
R41 VNW.t0 VNW.t1 310.079
R42 VNW VNW.t0 259.69
R43 VPW.t3 VPW.t4 1181.82
R44 VPW.t2 VPW.t3 1181.82
R45 VPW.t1 VPW.t2 1181.82
R46 VPW.t0 VPW.t1 1181.82
R47 VPW VPW.t0 989.774
C0 VDD a_28_68# 0.2493f
C1 Y VSS 0.38922f
C2 A VSS 0.01447f
C3 A Y 0.00226f
C4 VDD VSS 0.03996f
C5 VDD Y 0.44393f
C6 VNW a_28_68# 0.37462f
C7 VDD A 0.01515f
C8 VNW VSS 0.00633f
C9 VNW Y 0.04333f
C10 VNW A 0.09117f
C11 VDD VNW 0.15421f
C12 VSS a_28_68# 0.21854f
C13 Y a_28_68# 0.41001f
C14 A a_28_68# 0.28733f
C15 VSS VPW 0.43273f
C16 Y VPW 0.08264f
C17 VDD VPW 0.327f
C18 A VPW 0.25492f
C19 VNW VPW 1.91914f
C20 a_28_68# VPW 0.50049f
C21 VNW.t4 VPW 0.22132f
C22 VNW.t3 VPW 0.0908f
C23 VNW.t2 VPW 0.0908f
C24 VNW.t1 VPW 0.0908f
C25 VNW.t0 VPW 0.08342f
C26 A.t1 VPW 0.09322f
C27 A.t0 VPW 0.06893f
C28 A.n0 VPW 0.13519f
C29 VDD.t1 VPW 0.02638f
C30 VDD.t0 VPW 0.02638f
C31 VDD.n0 VPW 0.05291f
C32 VDD.t3 VPW 0.02638f
C33 VDD.t2 VPW 0.02638f
C34 VDD.n1 VPW 0.05291f
C35 VDD.t4 VPW 0.13271f
C36 VDD.n2 VPW 0.37608f
C37 VDD.n3 VPW 0.13302f
C38 Y.t7 VPW 0.04553f
C39 Y.t6 VPW 0.04553f
C40 Y.n0 VPW 0.09874f
C41 Y.t1 VPW 0.04553f
C42 Y.t0 VPW 0.04553f
C43 Y.n1 VPW 0.09874f
C44 Y.t5 VPW 0.03299f
C45 Y.t4 VPW 0.03299f
C46 Y.n2 VPW 0.06599f
C47 Y.n3 VPW 0.06842f
C48 Y.n4 VPW 0.23488f
C49 Y.n5 VPW 0.23488f
C50 Y.t3 VPW 0.03299f
C51 Y.t2 VPW 0.03299f
C52 Y.n6 VPW 0.06599f
C53 Y.n7 VPW 0.06842f
C54 VSS.t4 VPW 0.01631f
C55 VSS.t0 VPW 0.01631f
C56 VSS.n0 VPW 0.03272f
C57 VSS.t3 VPW 0.01631f
C58 VSS.t1 VPW 0.01631f
C59 VSS.n1 VPW 0.03272f
C60 VSS.t2 VPW 0.08511f
C61 VSS.n2 VPW 0.29709f
C62 VSS.n3 VPW 0.1135f
.ends

* NGSPICE file created from gf180mcu_as_sc_mcu7t3v3__buff_8.ext - technology: gf180mcuD

.subckt gf180mcu_as_sc_mcu7t3v3__buff_8 VDD VNW VPW VSS A Y
X0 VSS.t7 a_172_68# Y.t3 VPW.t5 nfet_03v3 ad=0.26p pd=1.52u as=0.26p ps=1.52u w=1u l=0.28u
X1 VDD.t1 A.t4 a_172_68# VNW.t1 pfet_03v3 ad=0.3588p pd=1.9u as=0.3588p ps=1.9u w=1.38u l=0.28u
X2 Y.t9 a_172_68# VDD.t4 VNW.t4 pfet_03v3 ad=0.3588p pd=1.9u as=0.3588p ps=1.9u w=1.38u l=0.28u
X3 a_172_68# A.t2 VSS.t0 VPW.t0 nfet_03v3 ad=0.26p pd=1.52u as=0.44p ps=2.88u w=1u l=0.28u
X4 VSS.t4 a_172_68# Y.t7 VPW.t9 nfet_03v3 ad=0.26p pd=1.52u as=0.26p ps=1.52u w=1u l=0.28u
X5 VDD.t7 a_172_68# Y.t12 VNW.t7 pfet_03v3 ad=0.3588p pd=1.9u as=0.3588p ps=1.9u w=1.38u l=0.28u
X6 Y.t0 a_172_68# VDD.t10 VNW.t10 pfet_03v3 ad=1.4904p pd=4.92u as=0.3588p ps=1.9u w=1.38u l=0.28u
X7 Y.t2 a_172_68# VSS.t9 VPW.t4 nfet_03v3 ad=0.26p pd=1.52u as=0.26p ps=1.52u w=1u l=0.28u
X8 Y.t13 a_172_68# VDD.t8 VNW.t8 pfet_03v3 ad=0.3588p pd=1.9u as=0.3588p ps=1.9u w=1.38u l=0.28u
X9 Y.t6 a_172_68# VSS.t5 VPW.t8 nfet_03v3 ad=0.26p pd=1.52u as=0.26p ps=1.52u w=1u l=0.28u
X10 a_172_68# A.t3 VDD.t0 VNW.t2 pfet_03v3 ad=0.3588p pd=1.9u as=0.3588p ps=1.9u w=1.38u l=0.28u
X11 VDD.t5 a_172_68# Y.t10 VNW.t5 pfet_03v3 ad=0.3588p pd=1.9u as=0.3588p ps=1.9u w=1.38u l=0.28u
X12 VSS.t8 a_172_68# a_172_68# VPW.t3 nfet_03v3 ad=0.26p pd=1.52u as=0.26p ps=1.52u w=1u l=0.28u
X13 VSS.t6 a_172_68# Y.t5 VPW.t7 nfet_03v3 ad=0.26p pd=1.52u as=0.26p ps=1.52u w=1u l=0.28u
X14 VDD.t3 a_172_68# a_172_68# VNW.t3 pfet_03v3 ad=0.3588p pd=1.9u as=0.3588p ps=1.9u w=1.38u l=0.28u
X15 a_172_68# A.t0 VSS.t1 VPW.t2 nfet_03v3 ad=0.26p pd=1.52u as=0.26p ps=1.52u w=1u l=0.28u
X16 Y.t11 a_172_68# VDD.t6 VNW.t6 pfet_03v3 ad=0.3588p pd=1.9u as=0.3588p ps=1.9u w=1.38u l=0.28u
X17 VDD.t9 a_172_68# Y.t1 VNW.t9 pfet_03v3 ad=0.3588p pd=1.9u as=0.3588p ps=1.9u w=1.38u l=0.28u
X18 Y.t4 a_172_68# VSS.t10 VPW.t6 nfet_03v3 ad=0.26p pd=1.52u as=0.26p ps=1.52u w=1u l=0.28u
X19 a_172_68# A.t5 VDD.t2 VNW.t0 pfet_03v3 ad=0.3588p pd=1.9u as=0.6072p ps=3.64u w=1.38u l=0.28u
X20 VSS.t2 A.t1 a_172_68# VPW.t1 nfet_03v3 ad=0.26p pd=1.52u as=0.26p ps=1.52u w=1u l=0.28u
X21 Y.t8 a_172_68# VSS.t3 VPW.t10 nfet_03v3 ad=1.08p pd=4.16u as=0.26p ps=1.52u w=1u l=0.28u
R0 VSS.n9 VSS.t0 10.6202
R1 VSS.n5 VSS.n4 3.59985
R2 VSS.n5 VSS.n3 3.3618
R3 VSS.n6 VSS.n2 3.3618
R4 VSS.n7 VSS.n1 3.3618
R5 VSS.n8 VSS.n0 3.35202
R6 VSS.n4 VSS.t3 1.6385
R7 VSS.n4 VSS.t4 1.6385
R8 VSS.n3 VSS.t5 1.6385
R9 VSS.n3 VSS.t6 1.6385
R10 VSS.n2 VSS.t10 1.6385
R11 VSS.n2 VSS.t7 1.6385
R12 VSS.n1 VSS.t9 1.6385
R13 VSS.n1 VSS.t8 1.6385
R14 VSS.n0 VSS.t1 1.6385
R15 VSS.n0 VSS.t2 1.6385
R16 VSS.n6 VSS.n5 0.2405
R17 VSS.n7 VSS.n6 0.2405
R18 VSS.n8 VSS.n7 0.2405
R19 VSS.n9 VSS.n8 0.2405
R20 VSS VSS.n9 0.0485
R21 Y.n6 Y.t8 8.3276
R22 Y.n7 Y.n5 6.46093
R23 Y.n8 Y.n3 6.46093
R24 Y.n9 Y.n1 6.46093
R25 Y.n6 Y.t0 4.24021
R26 Y.n7 Y.n4 2.92137
R27 Y.n8 Y.n2 2.92137
R28 Y.n9 Y.n0 2.92137
R29 Y.n5 Y.t7 1.6385
R30 Y.n5 Y.t6 1.6385
R31 Y.n3 Y.t5 1.6385
R32 Y.n3 Y.t4 1.6385
R33 Y.n1 Y.t3 1.6385
R34 Y.n1 Y.t2 1.6385
R35 Y.n4 Y.t1 1.31934
R36 Y.n4 Y.t13 1.31934
R37 Y.n2 Y.t12 1.31934
R38 Y.n2 Y.t11 1.31934
R39 Y.n0 Y.t10 1.31934
R40 Y.n0 Y.t9 1.31934
R41 Y.n7 Y.n6 0.35172
R42 Y.n8 Y.n7 0.35172
R43 Y.n9 Y.n8 0.35172
R44 Y Y.n9 0.0257439
R45 VDD.n9 VDD.t2 12.7019
R46 VDD.n8 VDD.n0 2.8842
R47 VDD.n5 VDD.n4 2.25949
R48 VDD.n7 VDD.n1 2.02731
R49 VDD.n6 VDD.n2 2.01949
R50 VDD.n5 VDD.n3 2.01949
R51 VDD.n0 VDD.t0 1.31934
R52 VDD.n0 VDD.t1 1.31934
R53 VDD.n1 VDD.t4 1.31934
R54 VDD.n1 VDD.t3 1.31934
R55 VDD.n2 VDD.t6 1.31934
R56 VDD.n2 VDD.t5 1.31934
R57 VDD.n3 VDD.t8 1.31934
R58 VDD.n3 VDD.t7 1.31934
R59 VDD.n4 VDD.t10 1.31934
R60 VDD.n4 VDD.t9 1.31934
R61 VDD.n6 VDD.n5 0.2405
R62 VDD.n7 VDD.n6 0.2405
R63 VDD.n8 VDD.n7 0.2405
R64 VDD.n9 VDD.n8 0.2405
R65 VDD VDD.n9 0.0485
R66 A.n0 A.t3 27.2451
R67 A.n0 A.t0 26.2023
R68 A.n1 A.t4 21.6398
R69 A.n2 A.t5 21.6398
R70 A.n1 A.t1 20.0755
R71 A.n2 A.t2 20.0755
R72 A.n1 A.n0 18.0883
R73 A.n2 A.n1 12.9783
R74 A A.n2 10.1444
R75 VNW.t9 VNW.t10 310.079
R76 VNW.t8 VNW.t9 310.079
R77 VNW.t7 VNW.t8 310.079
R78 VNW.t6 VNW.t7 310.079
R79 VNW.t5 VNW.t6 310.079
R80 VNW.t4 VNW.t5 310.079
R81 VNW.t3 VNW.t4 310.079
R82 VNW.t2 VNW.t3 310.079
R83 VNW.t1 VNW.t2 310.079
R84 VNW.t0 VNW.t1 310.079
R85 VNW VNW.t0 259.69
R86 VPW.t9 VPW.t10 1181.82
R87 VPW.t8 VPW.t9 1181.82
R88 VPW.t7 VPW.t8 1181.82
R89 VPW.t6 VPW.t7 1181.82
R90 VPW.t5 VPW.t6 1181.82
R91 VPW.t4 VPW.t5 1181.82
R92 VPW.t3 VPW.t4 1181.82
R93 VPW.t2 VPW.t3 1181.82
R94 VPW.t1 VPW.t2 1181.82
R95 VPW.t0 VPW.t1 1181.82
R96 VPW VPW.t0 989.774
C0 a_172_68# A 0.32015f
C1 a_172_68# Y 0.41174f
C2 VDD VSS 0.0195f
C3 VDD VNW 0.33024f
C4 VSS VNW 0.00581f
C5 VDD A 0.10686f
C6 a_172_68# VDD 0.82118f
C7 VSS A 0.10415f
C8 VNW A 0.26728f
C9 a_172_68# VSS 0.47884f
C10 a_172_68# VNW 0.75976f
C11 VDD Y 1.19879f
C12 Y VSS 0.61608f
C13 Y VNW 0.12594f
C14 VSS VPW 0.68466f
C15 Y VPW 0.11261f
C16 VDD VPW 0.45973f
C17 A VPW 0.38824f
C18 VNW VPW 3.49795f
C19 a_172_68# VPW 0.91088f
C20 VNW.t10 VPW 0.29808f
C21 VNW.t9 VPW 0.10889f
C22 VNW.t8 VPW 0.10889f
C23 VNW.t7 VPW 0.10889f
C24 VNW.t6 VPW 0.10889f
C25 VNW.t5 VPW 0.10889f
C26 VNW.t4 VPW 0.10889f
C27 VNW.t3 VPW 0.10889f
C28 VNW.t2 VPW 0.10889f
C29 VNW.t1 VPW 0.10889f
C30 VNW.t0 VPW 0.10004f
C31 A.t5 VPW 0.06895f
C32 A.t2 VPW 0.05181f
C33 A.t4 VPW 0.06895f
C34 A.t1 VPW 0.05181f
C35 A.t3 VPW 0.07732f
C36 A.t0 VPW 0.06096f
C37 A.n0 VPW 0.1005f
C38 A.n1 VPW 0.14402f
C39 A.n2 VPW 0.14887f
C40 VDD.t2 VPW 0.10158f
C41 VDD.t0 VPW 0.03715f
C42 VDD.t1 VPW 0.03715f
C43 VDD.n0 VPW 0.07895f
C44 VDD.t4 VPW 0.03715f
C45 VDD.t3 VPW 0.03715f
C46 VDD.n1 VPW 0.08165f
C47 VDD.t6 VPW 0.03715f
C48 VDD.t5 VPW 0.03715f
C49 VDD.n2 VPW 0.08135f
C50 VDD.t8 VPW 0.03715f
C51 VDD.t7 VPW 0.03715f
C52 VDD.n3 VPW 0.08135f
C53 VDD.t10 VPW 0.03715f
C54 VDD.t9 VPW 0.03715f
C55 VDD.n4 VPW 0.12153f
C56 VDD.n5 VPW 0.59694f
C57 VDD.n6 VPW 0.25892f
C58 VDD.n7 VPW 0.26005f
C59 VDD.n8 VPW 0.25869f
C60 VDD.n9 VPW 0.16416f
C61 Y.t10 VPW 0.04147f
C62 Y.t9 VPW 0.04147f
C63 Y.n0 VPW 0.08879f
C64 Y.t3 VPW 0.03005f
C65 Y.t2 VPW 0.03005f
C66 Y.n1 VPW 0.0606f
C67 Y.t12 VPW 0.04147f
C68 Y.t11 VPW 0.04147f
C69 Y.n2 VPW 0.08879f
C70 Y.t5 VPW 0.03005f
C71 Y.t4 VPW 0.03005f
C72 Y.n3 VPW 0.0606f
C73 Y.t1 VPW 0.04147f
C74 Y.t13 VPW 0.04147f
C75 Y.n4 VPW 0.08879f
C76 Y.t7 VPW 0.03005f
C77 Y.t6 VPW 0.03005f
C78 Y.n5 VPW 0.0606f
C79 Y.t0 VPW 0.2543f
C80 Y.t8 VPW 0.23103f
C81 Y.n6 VPW 0.30144f
C82 Y.n7 VPW 0.25113f
C83 Y.n8 VPW 0.25113f
C84 Y.n9 VPW 0.18075f
C85 VSS.t0 VPW 0.04473f
C86 VSS.t1 VPW 0.01535f
C87 VSS.t2 VPW 0.01535f
C88 VSS.n0 VPW 0.03186f
C89 VSS.t9 VPW 0.01535f
C90 VSS.t8 VPW 0.01535f
C91 VSS.n1 VPW 0.03206f
C92 VSS.t10 VPW 0.01535f
C93 VSS.t7 VPW 0.01535f
C94 VSS.n2 VPW 0.03201f
C95 VSS.t5 VPW 0.01535f
C96 VSS.t6 VPW 0.01535f
C97 VSS.n3 VPW 0.03201f
C98 VSS.t3 VPW 0.01535f
C99 VSS.t4 VPW 0.01535f
C100 VSS.n4 VPW 0.04583f
C101 VSS.n5 VPW 0.33424f
C102 VSS.n6 VPW 0.14024f
C103 VSS.n7 VPW 0.14101f
C104 VSS.n8 VPW 0.13862f
C105 VSS.n9 VPW 0.08701f
.ends

* NGSPICE file created from gf180mcu_as_sc_mcu7t3v3__clkbuff_12.ext - technology: gf180mcuD

.subckt gf180mcu_as_sc_mcu7t3v3__clkbuff_12 VDD VNW VPW VSS A Y
X0 VSS.t6 a_172_68# Y.t21 VPW.t15 nfet_03v3 ad=0.7092p pd=3.41u as=0.1872p ps=1.24u w=0.72u l=0.28u
X1 VSS.t13 a_172_68# Y.t11 VPW.t5 nfet_03v3 ad=0.1872p pd=1.24u as=0.1872p ps=1.24u w=0.72u l=0.28u
X2 VDD.t1 A.t6 a_172_68# VNW.t1 pfet_03v3 ad=0.3588p pd=1.9u as=0.3588p ps=1.9u w=1.38u l=0.28u
X3 Y.t4 a_172_68# VDD.t4 VNW.t4 pfet_03v3 ad=0.3588p pd=1.9u as=0.3588p ps=1.9u w=1.38u l=0.28u
X4 Y.t5 a_172_68# VDD.t12 VNW.t12 pfet_03v3 ad=0.3588p pd=1.9u as=0.3588p ps=1.9u w=1.38u l=0.28u
X5 VDD.t15 a_172_68# Y.t2 VNW.t15 pfet_03v3 ad=1.3593p pd=4.73u as=0.3588p ps=1.9u w=1.38u l=0.28u
X6 a_172_68# A.t3 VSS.t2 VPW.t0 nfet_03v3 ad=0.1872p pd=1.24u as=0.3168p ps=2.32u w=0.72u l=0.28u
X7 VSS.t10 a_172_68# Y.t15 VPW.t9 nfet_03v3 ad=0.1872p pd=1.24u as=0.1872p ps=1.24u w=0.72u l=0.28u
X8 VDD.t7 a_172_68# Y.t3 VNW.t7 pfet_03v3 ad=0.3588p pd=1.9u as=0.3588p ps=1.9u w=1.38u l=0.28u
X9 Y.t0 a_172_68# VDD.t10 VNW.t10 pfet_03v3 ad=0.36915p pd=1.915u as=0.3588p ps=1.9u w=1.38u l=0.28u
X10 VDD.t13 a_172_68# Y.t6 VNW.t13 pfet_03v3 ad=0.3588p pd=1.9u as=0.3588p ps=1.9u w=1.38u l=0.28u
X11 Y.t20 a_172_68# VSS.t14 VPW.t14 nfet_03v3 ad=0.1872p pd=1.24u as=0.1872p ps=1.24u w=0.72u l=0.28u
X12 Y.t10 a_172_68# VSS.t5 VPW.t4 nfet_03v3 ad=0.1872p pd=1.24u as=0.1872p ps=1.24u w=0.72u l=0.28u
X13 Y.t22 a_172_68# VDD.t8 VNW.t8 pfet_03v3 ad=0.3588p pd=1.9u as=0.3588p ps=1.9u w=1.38u l=0.28u
X14 Y.t14 a_172_68# VSS.t7 VPW.t8 nfet_03v3 ad=0.1872p pd=1.24u as=0.1872p ps=1.24u w=0.72u l=0.28u
X15 a_172_68# A.t5 VDD.t0 VNW.t2 pfet_03v3 ad=0.3588p pd=1.9u as=0.3588p ps=1.9u w=1.38u l=0.28u
X16 VSS.t9 a_172_68# Y.t19 VPW.t13 nfet_03v3 ad=0.1872p pd=1.24u as=0.1872p ps=1.24u w=0.72u l=0.28u
X17 VDD.t5 a_172_68# Y.t8 VNW.t5 pfet_03v3 ad=0.3588p pd=1.9u as=0.3588p ps=1.9u w=1.38u l=0.28u
X18 VSS.t3 A.t0 a_172_68# VPW.t3 nfet_03v3 ad=0.1872p pd=1.24u as=0.1872p ps=1.24u w=0.72u l=0.28u
X19 VSS.t15 a_172_68# Y.t13 VPW.t7 nfet_03v3 ad=0.1872p pd=1.24u as=0.1872p ps=1.24u w=0.72u l=0.28u
X20 VSS.t4 a_172_68# Y.t17 VPW.t11 nfet_03v3 ad=0.1872p pd=1.24u as=0.1926p ps=1.255u w=0.72u l=0.28u
X21 VDD.t3 A.t4 a_172_68# VNW.t3 pfet_03v3 ad=0.3588p pd=1.9u as=0.3588p ps=1.9u w=1.38u l=0.28u
X22 Y.t18 a_172_68# VSS.t12 VPW.t12 nfet_03v3 ad=0.1872p pd=1.24u as=0.1872p ps=1.24u w=0.72u l=0.28u
X23 Y.t1 a_172_68# VDD.t14 VNW.t14 pfet_03v3 ad=0.3588p pd=1.9u as=0.3588p ps=1.9u w=1.38u l=0.28u
X24 a_172_68# A.t1 VSS.t1 VPW.t2 nfet_03v3 ad=0.1872p pd=1.24u as=0.1872p ps=1.24u w=0.72u l=0.28u
X25 Y.t7 a_172_68# VDD.t6 VNW.t6 pfet_03v3 ad=0.3588p pd=1.9u as=0.3588p ps=1.9u w=1.38u l=0.28u
X26 VDD.t9 a_172_68# Y.t9 VNW.t9 pfet_03v3 ad=0.3588p pd=1.9u as=0.3588p ps=1.9u w=1.38u l=0.28u
X27 Y.t12 a_172_68# VSS.t8 VPW.t6 nfet_03v3 ad=0.1872p pd=1.24u as=0.1872p ps=1.24u w=0.72u l=0.28u
X28 a_172_68# A.t7 VDD.t2 VNW.t0 pfet_03v3 ad=0.3588p pd=1.9u as=0.6072p ps=3.64u w=1.38u l=0.28u
X29 VDD.t11 a_172_68# Y.t23 VNW.t11 pfet_03v3 ad=0.3588p pd=1.9u as=0.36915p ps=1.915u w=1.38u l=0.28u
X30 VSS.t0 A.t2 a_172_68# VPW.t1 nfet_03v3 ad=0.1872p pd=1.24u as=0.1872p ps=1.24u w=0.72u l=0.28u
X31 Y.t16 a_172_68# VSS.t11 VPW.t10 nfet_03v3 ad=0.1926p pd=1.255u as=0.1872p ps=1.24u w=0.72u l=0.28u
R0 VSS.n7 VSS.t6 8.90159
R1 VSS.n14 VSS.t2 8.66354
R2 VSS.n12 VSS.n1 6.38854
R3 VSS.n7 VSS.n6 6.38659
R4 VSS.n8 VSS.n5 6.38659
R5 VSS.n9 VSS.n4 6.38659
R6 VSS.n10 VSS.n3 6.38659
R7 VSS.n11 VSS.n2 6.38659
R8 VSS.n13 VSS.n0 6.38659
R9 VSS.n6 VSS.t14 2.2755
R10 VSS.n6 VSS.t9 2.2755
R11 VSS.n5 VSS.t12 2.2755
R12 VSS.n5 VSS.t4 2.2755
R13 VSS.n4 VSS.t11 2.2755
R14 VSS.n4 VSS.t10 2.2755
R15 VSS.n3 VSS.t7 2.2755
R16 VSS.n3 VSS.t15 2.2755
R17 VSS.n2 VSS.t8 2.2755
R18 VSS.n2 VSS.t13 2.2755
R19 VSS.n1 VSS.t5 2.2755
R20 VSS.n1 VSS.t3 2.2755
R21 VSS.n0 VSS.t1 2.2755
R22 VSS.n0 VSS.t0 2.2755
R23 VSS.n9 VSS.n8 0.24275
R24 VSS.n8 VSS.n7 0.2405
R25 VSS.n10 VSS.n9 0.2405
R26 VSS.n11 VSS.n10 0.2405
R27 VSS.n12 VSS.n11 0.2405
R28 VSS.n13 VSS.n12 0.2405
R29 VSS.n14 VSS.n13 0.2405
R30 VSS VSS.n14 0.0485
R31 Y.n8 Y.n7 7.08311
R32 Y.n16 Y.n15 6.62528
R33 Y.n17 Y.n13 6.62528
R34 Y.n18 Y.n11 6.62528
R35 Y.n9 Y.n5 6.45702
R36 Y.n8 Y.n6 6.45702
R37 Y.n3 Y.n2 3.34789
R38 Y.n16 Y.n14 2.89985
R39 Y.n17 Y.n12 2.89985
R40 Y.n18 Y.n10 2.89985
R41 Y.n4 Y.n0 2.7218
R42 Y.n3 Y.n1 2.7218
R43 Y.n11 Y.t16 2.40675
R44 Y.n15 Y.t21 2.2755
R45 Y.n15 Y.t20 2.2755
R46 Y.n13 Y.t19 2.2755
R47 Y.n13 Y.t18 2.2755
R48 Y.n11 Y.t17 2.2755
R49 Y.n5 Y.t15 2.2755
R50 Y.n5 Y.t14 2.2755
R51 Y.n7 Y.t11 2.2755
R52 Y.n7 Y.t10 2.2755
R53 Y.n6 Y.t13 2.2755
R54 Y.n6 Y.t12 2.2755
R55 Y.n10 Y.t0 1.39543
R56 Y.n14 Y.t2 1.31934
R57 Y.n14 Y.t1 1.31934
R58 Y.n12 Y.t6 1.31934
R59 Y.n12 Y.t5 1.31934
R60 Y.n10 Y.t23 1.31934
R61 Y.n0 Y.t9 1.31934
R62 Y.n0 Y.t22 1.31934
R63 Y.n1 Y.t3 1.31934
R64 Y.n1 Y.t7 1.31934
R65 Y.n2 Y.t8 1.31934
R66 Y.n2 Y.t4 1.31934
R67 Y.n9 Y.n8 0.626587
R68 Y.n4 Y.n3 0.626587
R69 Y.n19 Y.n18 0.288322
R70 Y.n17 Y.n16 0.285649
R71 Y.n18 Y.n17 0.285649
R72 Y.n19 Y.n4 0.106152
R73 Y.n19 Y.n9 0.0787609
R74 Y Y.n19 0.020995
R75 VDD.n14 VDD.t2 6.67195
R76 VDD.n13 VDD.n0 5.3805
R77 VDD.n10 VDD.n3 5.37854
R78 VDD.n12 VDD.n1 5.37659
R79 VDD.n11 VDD.n2 5.37659
R80 VDD.n7 VDD.t15 3.56854
R81 VDD.n9 VDD.n4 2.0097
R82 VDD.n8 VDD.n5 2.0097
R83 VDD.n7 VDD.n6 2.0097
R84 VDD.n0 VDD.t0 1.31934
R85 VDD.n0 VDD.t1 1.31934
R86 VDD.n1 VDD.t4 1.31934
R87 VDD.n1 VDD.t3 1.31934
R88 VDD.n2 VDD.t6 1.31934
R89 VDD.n2 VDD.t5 1.31934
R90 VDD.n3 VDD.t8 1.31934
R91 VDD.n3 VDD.t7 1.31934
R92 VDD.n4 VDD.t10 1.31934
R93 VDD.n4 VDD.t9 1.31934
R94 VDD.n5 VDD.t12 1.31934
R95 VDD.n5 VDD.t11 1.31934
R96 VDD.n6 VDD.t14 1.31934
R97 VDD.n6 VDD.t13 1.31934
R98 VDD.n9 VDD.n8 0.24275
R99 VDD.n8 VDD.n7 0.2405
R100 VDD.n10 VDD.n9 0.2405
R101 VDD.n11 VDD.n10 0.2405
R102 VDD.n12 VDD.n11 0.2405
R103 VDD.n13 VDD.n12 0.2405
R104 VDD.n14 VDD.n13 0.2405
R105 VDD VDD.n14 0.0485
R106 A.n0 A.t4 22.813
R107 A.n1 A.t5 22.813
R108 A.n3 A.t6 22.813
R109 A.n2 A.t7 22.813
R110 A.n0 A.t0 22.6826
R111 A.n1 A.t1 22.6826
R112 A.n3 A.t2 22.6826
R113 A.n2 A.t3 22.6826
R114 A.n1 A.n0 13.1241
R115 A.n3 A.n2 13.1241
R116 A.n4 A.n1 7.54657
R117 A.n4 A.n3 5.57803
R118 A A.n4 1.8402
R119 VNW.t10 VNW.t11 315.892
R120 VNW.t14 VNW.t15 310.079
R121 VNW.t13 VNW.t14 310.079
R122 VNW.t12 VNW.t13 310.079
R123 VNW.t11 VNW.t12 310.079
R124 VNW.t9 VNW.t10 310.079
R125 VNW.t8 VNW.t9 310.079
R126 VNW.t7 VNW.t8 310.079
R127 VNW.t6 VNW.t7 310.079
R128 VNW.t5 VNW.t6 310.079
R129 VNW.t4 VNW.t5 310.079
R130 VNW.t3 VNW.t4 310.079
R131 VNW.t2 VNW.t3 310.079
R132 VNW.t1 VNW.t2 310.079
R133 VNW.t0 VNW.t1 310.079
R134 VNW VNW.t0 259.69
R135 VPW.t10 VPW.t11 1203.98
R136 VPW.t14 VPW.t15 1181.82
R137 VPW.t13 VPW.t14 1181.82
R138 VPW.t12 VPW.t13 1181.82
R139 VPW.t11 VPW.t12 1181.82
R140 VPW.t9 VPW.t10 1181.82
R141 VPW.t8 VPW.t9 1181.82
R142 VPW.t7 VPW.t8 1181.82
R143 VPW.t6 VPW.t7 1181.82
R144 VPW.t5 VPW.t6 1181.82
R145 VPW.t4 VPW.t5 1181.82
R146 VPW.t3 VPW.t4 1181.82
R147 VPW.t2 VPW.t3 1181.82
R148 VPW.t1 VPW.t2 1181.82
R149 VPW.t0 VPW.t1 1181.82
R150 VPW VPW.t0 989.774
C0 A a_172_68# 1.25199f
C1 a_172_68# Y 1.5956f
C2 A VNW 0.3485f
C3 VNW Y 0.15681f
C4 a_172_68# VSS 0.5789f
C5 a_172_68# VDD 0.83471f
C6 VNW VSS 0.00789f
C7 VNW VDD 0.4475f
C8 VNW a_172_68# 1.09919f
C9 A Y 0.00239f
C10 A VSS 0.08594f
C11 Y VSS 0.90576f
C12 A VDD 0.10197f
C13 Y VDD 1.75456f
C14 VDD VSS 0.04192f
C15 VSS VPW 0.90926f
C16 Y VPW 0.15516f
C17 VDD VPW 0.64825f
C18 A VPW 0.96523f
C19 VNW VPW 4.71364f
C20 a_172_68# VPW 1.64589f
C21 VNW.t15 VPW 0.29041f
C22 VNW.t14 VPW 0.1109f
C23 VNW.t13 VPW 0.1109f
C24 VNW.t12 VPW 0.1109f
C25 VNW.t11 VPW 0.11193f
C26 VNW.t10 VPW 0.11193f
C27 VNW.t9 VPW 0.1109f
C28 VNW.t8 VPW 0.1109f
C29 VNW.t7 VPW 0.1109f
C30 VNW.t6 VPW 0.1109f
C31 VNW.t5 VPW 0.1109f
C32 VNW.t4 VPW 0.1109f
C33 VNW.t3 VPW 0.1109f
C34 VNW.t2 VPW 0.1109f
C35 VNW.t1 VPW 0.1109f
C36 VNW.t0 VPW 0.10188f
C37 A.t5 VPW 0.08772f
C38 A.t1 VPW 0.05558f
C39 A.t4 VPW 0.08772f
C40 A.t0 VPW 0.05558f
C41 A.n0 VPW 0.1673f
C42 A.n1 VPW 0.18112f
C43 A.t6 VPW 0.08772f
C44 A.t2 VPW 0.05558f
C45 A.t7 VPW 0.08772f
C46 A.t3 VPW 0.05558f
C47 A.n2 VPW 0.17728f
C48 A.n3 VPW 0.17191f
C49 A.n4 VPW 0.10592f
C50 VDD.t2 VPW 0.09501f
C51 VDD.t0 VPW 0.03243f
C52 VDD.t1 VPW 0.03243f
C53 VDD.n0 VPW 0.06572f
C54 VDD.t4 VPW 0.03243f
C55 VDD.t3 VPW 0.03243f
C56 VDD.n1 VPW 0.0657f
C57 VDD.t6 VPW 0.03243f
C58 VDD.t5 VPW 0.03243f
C59 VDD.n2 VPW 0.0657f
C60 VDD.t8 VPW 0.03243f
C61 VDD.t7 VPW 0.03243f
C62 VDD.n3 VPW 0.06571f
C63 VDD.t10 VPW 0.03243f
C64 VDD.t9 VPW 0.03243f
C65 VDD.n4 VPW 0.07057f
C66 VDD.t12 VPW 0.03243f
C67 VDD.t11 VPW 0.03243f
C68 VDD.n5 VPW 0.07057f
C69 VDD.t14 VPW 0.03243f
C70 VDD.t13 VPW 0.03243f
C71 VDD.n6 VPW 0.07057f
C72 VDD.t15 VPW 0.18601f
C73 VDD.n7 VPW 0.52068f
C74 VDD.n8 VPW 0.22493f
C75 VDD.n9 VPW 0.22493f
C76 VDD.n10 VPW 0.20819f
C77 VDD.n11 VPW 0.208f
C78 VDD.n12 VPW 0.208f
C79 VDD.n13 VPW 0.20819f
C80 VDD.n14 VPW 0.15086f
C81 Y.t9 VPW 0.059f
C82 Y.t22 VPW 0.059f
C83 Y.n0 VPW 0.12036f
C84 Y.t3 VPW 0.059f
C85 Y.t7 VPW 0.059f
C86 Y.n1 VPW 0.12036f
C87 Y.t8 VPW 0.059f
C88 Y.t4 VPW 0.059f
C89 Y.n2 VPW 0.14496f
C90 Y.n3 VPW 0.29026f
C91 Y.n4 VPW 0.14173f
C92 Y.t15 VPW 0.03078f
C93 Y.t14 VPW 0.03078f
C94 Y.n5 VPW 0.06224f
C95 Y.t13 VPW 0.03078f
C96 Y.t12 VPW 0.03078f
C97 Y.n6 VPW 0.06224f
C98 Y.t11 VPW 0.03078f
C99 Y.t10 VPW 0.03078f
C100 Y.n7 VPW 0.07211f
C101 Y.n8 VPW 0.26524f
C102 Y.n9 VPW 0.11921f
C103 Y.t23 VPW 0.059f
C104 Y.t0 VPW 0.0624f
C105 Y.n10 VPW 0.129f
C106 Y.t17 VPW 0.03078f
C107 Y.t16 VPW 0.03256f
C108 Y.n11 VPW 0.06551f
C109 Y.t6 VPW 0.059f
C110 Y.t5 VPW 0.059f
C111 Y.n12 VPW 0.12559f
C112 Y.t19 VPW 0.03078f
C113 Y.t18 VPW 0.03078f
C114 Y.n13 VPW 0.06373f
C115 Y.t2 VPW 0.059f
C116 Y.t1 VPW 0.059f
C117 Y.n14 VPW 0.12559f
C118 Y.t21 VPW 0.03078f
C119 Y.t20 VPW 0.03078f
C120 Y.n15 VPW 0.06373f
C121 Y.n16 VPW 0.32033f
C122 Y.n17 VPW 0.43409f
C123 Y.n18 VPW 0.43533f
C124 Y.n19 VPW 0.16142f
C125 VSS.t2 VPW 0.03258f
C126 VSS.t1 VPW 0.01178f
C127 VSS.t0 VPW 0.01178f
C128 VSS.n0 VPW 0.02368f
C129 VSS.t5 VPW 0.01178f
C130 VSS.t3 VPW 0.01178f
C131 VSS.n1 VPW 0.02368f
C132 VSS.t8 VPW 0.01178f
C133 VSS.t13 VPW 0.01178f
C134 VSS.n2 VPW 0.02368f
C135 VSS.t7 VPW 0.01178f
C136 VSS.t15 VPW 0.01178f
C137 VSS.n3 VPW 0.02368f
C138 VSS.t11 VPW 0.01178f
C139 VSS.t10 VPW 0.01178f
C140 VSS.n4 VPW 0.02367f
C141 VSS.t12 VPW 0.01178f
C142 VSS.t4 VPW 0.01178f
C143 VSS.n5 VPW 0.02367f
C144 VSS.t14 VPW 0.01178f
C145 VSS.t9 VPW 0.01178f
C146 VSS.n6 VPW 0.02367f
C147 VSS.t6 VPW 0.07323f
C148 VSS.n7 VPW 0.28506f
C149 VSS.n8 VPW 0.13257f
C150 VSS.n9 VPW 0.13257f
C151 VSS.n10 VPW 0.13258f
C152 VSS.n11 VPW 0.13258f
C153 VSS.n12 VPW 0.13257f
C154 VSS.n13 VPW 0.13258f
C155 VSS.n14 VPW 0.09137f
.ends

* NGSPICE file created from gf180mcu_as_sc_mcu7t3v3__clkbuff_4.ext - technology: gf180mcuD

.subckt gf180mcu_as_sc_mcu7t3v3__clkbuff_4 VDD VNW VPW VSS A Y
X0 Y.t7 a_28_68# VDD.t1 VNW.t1 pfet_03v3 ad=0.3588p pd=1.9u as=0.3588p ps=1.9u w=1.38u l=0.28u
X1 VDD.t4 a_28_68# Y.t0 VNW.t4 pfet_03v3 ad=1.1592p pd=4.44u as=0.3588p ps=1.9u w=1.38u l=0.28u
X2 VSS.t0 A.t0 a_28_68# VPW.t0 nfet_03v3 ad=0.1872p pd=1.24u as=0.3168p ps=2.32u w=0.72u l=0.28u
X3 VSS.t3 a_28_68# Y.t5 VPW.t4 nfet_03v3 ad=0.6048p pd=3.12u as=0.1872p ps=1.24u w=0.72u l=0.28u
X4 VDD.t2 a_28_68# Y.t1 VNW.t2 pfet_03v3 ad=0.3588p pd=1.9u as=0.3588p ps=1.9u w=1.38u l=0.28u
X5 Y.t4 a_28_68# VSS.t4 VPW.t3 nfet_03v3 ad=0.1872p pd=1.24u as=0.1872p ps=1.24u w=0.72u l=0.28u
X6 Y.t6 a_28_68# VDD.t3 VNW.t3 pfet_03v3 ad=0.3588p pd=1.9u as=0.3588p ps=1.9u w=1.38u l=0.28u
X7 VSS.t2 a_28_68# Y.t3 VPW.t2 nfet_03v3 ad=0.1872p pd=1.24u as=0.1872p ps=1.24u w=0.72u l=0.28u
X8 VDD.t0 A.t1 a_28_68# VNW.t0 pfet_03v3 ad=0.3588p pd=1.9u as=0.6072p ps=3.64u w=1.38u l=0.28u
X9 Y.t2 a_28_68# VSS.t1 VPW.t1 nfet_03v3 ad=0.1872p pd=1.24u as=0.1872p ps=1.24u w=0.72u l=0.28u
R0 VSS.n2 VSS.t3 8.90159
R1 VSS.n2 VSS.n1 6.38659
R2 VSS.n3 VSS.n0 6.38659
R3 VSS.n1 VSS.t4 2.2755
R4 VSS.n1 VSS.t2 2.2755
R5 VSS.n0 VSS.t1 2.2755
R6 VSS.n0 VSS.t0 2.2755
R7 VSS.n3 VSS.n2 0.2405
R8 VSS VSS.n3 0.1685
R9 Y.n7 Y.n6 6.3005
R10 Y.n3 Y.n2 6.3005
R11 Y.n5 Y.n0 2.8067
R12 Y.n4 Y.n1 2.8067
R13 Y.n2 Y.t3 2.2755
R14 Y.n2 Y.t2 2.2755
R15 Y.n6 Y.t5 2.2755
R16 Y.n6 Y.t4 2.2755
R17 Y.n1 Y.t1 1.31934
R18 Y.n1 Y.t7 1.31934
R19 Y.n0 Y.t0 1.31934
R20 Y.n0 Y.t6 1.31934
R21 Y.n5 Y.n4 0.381026
R22 Y.n7 Y.n5 0.272778
R23 Y.n4 Y.n3 0.272778
R24 Y Y.n7 0.0392342
R25 Y.n3 Y 0.0392342
R26 VDD.n3 VDD.n0 5.28659
R27 VDD.n2 VDD.n1 5.28659
R28 VDD.n2 VDD.t4 3.57833
R29 VDD.n0 VDD.t1 1.31934
R30 VDD.n0 VDD.t0 1.31934
R31 VDD.n1 VDD.t3 1.31934
R32 VDD.n1 VDD.t2 1.31934
R33 VDD.n3 VDD.n2 0.2405
R34 VDD VDD.n3 0.1685
R35 A.n0 A.t0 26.0347
R36 A.n0 A.t1 25.9788
R37 A A.n0 8.04519
R38 VNW.t3 VNW.t4 310.079
R39 VNW.t2 VNW.t3 310.079
R40 VNW.t1 VNW.t2 310.079
R41 VNW.t0 VNW.t1 310.079
R42 VNW VNW.t0 259.69
R43 VPW.t3 VPW.t4 1181.82
R44 VPW.t2 VPW.t3 1181.82
R45 VPW.t1 VPW.t2 1181.82
R46 VPW.t0 VPW.t1 1181.82
R47 VPW VPW.t0 989.774
C0 VSS a_28_68# 0.25135f
C1 Y a_28_68# 0.41701f
C2 A a_28_68# 0.2966f
C3 VDD a_28_68# 0.24921f
C4 Y VSS 0.31094f
C5 A VSS 0.01447f
C6 A Y 0.00226f
C7 VDD VSS 0.03377f
C8 VDD Y 0.44372f
C9 VNW a_28_68# 0.37462f
C10 VDD A 0.01515f
C11 VNW VSS 0.00604f
C12 VNW Y 0.04333f
C13 VNW A 0.09117f
C14 VDD VNW 0.15421f
C15 VSS VPW 0.41503f
C16 Y VPW 0.09249f
C17 VDD VPW 0.32858f
C18 A VPW 0.28897f
C19 VNW VPW 1.9191f
C20 a_28_68# VPW 0.62209f
C21 VNW.t4 VPW 0.22123f
C22 VNW.t3 VPW 0.09076f
C23 VNW.t2 VPW 0.09076f
C24 VNW.t1 VPW 0.09076f
C25 VNW.t0 VPW 0.08339f
C26 A.t1 VPW 0.09532f
C27 A.t0 VPW 0.06345f
C28 A.n0 VPW 0.14528f
C29 VDD.t1 VPW 0.02619f
C30 VDD.t0 VPW 0.02619f
C31 VDD.n0 VPW 0.05253f
C32 VDD.t3 VPW 0.02619f
C33 VDD.t2 VPW 0.02619f
C34 VDD.n1 VPW 0.05253f
C35 VDD.t4 VPW 0.13175f
C36 VDD.n2 VPW 0.37338f
C37 VDD.n3 VPW 0.13206f
C38 Y.t0 VPW 0.04562f
C39 Y.t6 VPW 0.04562f
C40 Y.n0 VPW 0.09894f
C41 Y.t1 VPW 0.04562f
C42 Y.t7 VPW 0.04562f
C43 Y.n1 VPW 0.09894f
C44 Y.t3 VPW 0.0238f
C45 Y.t2 VPW 0.0238f
C46 Y.n2 VPW 0.0476f
C47 Y.n3 VPW 0.06855f
C48 Y.n4 VPW 0.24615f
C49 Y.n5 VPW 0.24615f
C50 Y.t5 VPW 0.0238f
C51 Y.t4 VPW 0.0238f
C52 Y.n6 VPW 0.0476f
C53 Y.n7 VPW 0.06855f
C54 VSS.t1 VPW 0.0124f
C55 VSS.t0 VPW 0.0124f
C56 VSS.n0 VPW 0.0249f
C57 VSS.t4 VPW 0.0124f
C58 VSS.t2 VPW 0.0124f
C59 VSS.n1 VPW 0.0249f
C60 VSS.t3 VPW 0.06649f
C61 VSS.n2 VPW 0.28636f
C62 VSS.n3 VPW 0.11982f
.ends

* NGSPICE file created from gf180mcu_as_sc_mcu7t3v3__clkbuff_8.ext - technology: gf180mcuD

.subckt gf180mcu_as_sc_mcu7t3v3__clkbuff_8 VDD VNW VPW VSS A Y
X0 VSS.t9 a_172_68# Y.t2 VPW.t5 nfet_03v3 ad=0.1872p pd=1.24u as=0.1872p ps=1.24u w=0.72u l=0.28u
X1 VDD.t2 A.t4 a_172_68# VNW.t1 pfet_03v3 ad=0.3588p pd=1.9u as=0.3588p ps=1.9u w=1.38u l=0.28u
X2 Y.t8 a_172_68# VDD.t3 VNW.t4 pfet_03v3 ad=0.3588p pd=1.9u as=0.3588p ps=1.9u w=1.38u l=0.28u
X3 a_172_68# A.t2 VSS.t2 VPW.t0 nfet_03v3 ad=0.1872p pd=1.24u as=0.3168p ps=2.32u w=0.72u l=0.28u
X4 VSS.t5 a_172_68# Y.t6 VPW.t9 nfet_03v3 ad=0.1872p pd=1.24u as=0.1872p ps=1.24u w=0.72u l=0.28u
X5 VDD.t6 a_172_68# Y.t11 VNW.t7 pfet_03v3 ad=0.3588p pd=1.9u as=0.3588p ps=1.9u w=1.38u l=0.28u
X6 Y.t0 a_172_68# VDD.t9 VNW.t10 pfet_03v3 ad=1.4904p pd=4.92u as=0.3588p ps=1.9u w=1.38u l=0.28u
X7 Y.t1 a_172_68# VSS.t4 VPW.t4 nfet_03v3 ad=0.1872p pd=1.24u as=0.1872p ps=1.24u w=0.72u l=0.28u
X8 Y.t12 a_172_68# VDD.t7 VNW.t8 pfet_03v3 ad=0.3588p pd=1.9u as=0.3588p ps=1.9u w=1.38u l=0.28u
X9 Y.t5 a_172_68# VSS.t3 VPW.t8 nfet_03v3 ad=0.1872p pd=1.24u as=0.1872p ps=1.24u w=0.72u l=0.28u
X10 a_172_68# A.t3 VDD.t0 VNW.t2 pfet_03v3 ad=0.3588p pd=1.9u as=0.3588p ps=1.9u w=1.38u l=0.28u
X11 VDD.t4 a_172_68# Y.t9 VNW.t5 pfet_03v3 ad=0.3588p pd=1.9u as=0.3588p ps=1.9u w=1.38u l=0.28u
X12 VSS.t10 a_172_68# a_172_68# VPW.t3 nfet_03v3 ad=0.1872p pd=1.24u as=0.1872p ps=1.24u w=0.72u l=0.28u
X13 VSS.t6 a_172_68# Y.t4 VPW.t7 nfet_03v3 ad=0.1872p pd=1.24u as=0.1872p ps=1.24u w=0.72u l=0.28u
X14 VDD.t10 a_172_68# a_172_68# VNW.t3 pfet_03v3 ad=0.3588p pd=1.9u as=0.3588p ps=1.9u w=1.38u l=0.28u
X15 a_172_68# A.t0 VSS.t1 VPW.t2 nfet_03v3 ad=0.1872p pd=1.24u as=0.1872p ps=1.24u w=0.72u l=0.28u
X16 Y.t10 a_172_68# VDD.t5 VNW.t6 pfet_03v3 ad=0.3588p pd=1.9u as=0.3588p ps=1.9u w=1.38u l=0.28u
X17 VDD.t8 a_172_68# Y.t13 VNW.t9 pfet_03v3 ad=0.3588p pd=1.9u as=0.3588p ps=1.9u w=1.38u l=0.28u
X18 Y.t3 a_172_68# VSS.t8 VPW.t6 nfet_03v3 ad=0.1872p pd=1.24u as=0.1872p ps=1.24u w=0.72u l=0.28u
X19 a_172_68# A.t5 VDD.t1 VNW.t0 pfet_03v3 ad=0.3588p pd=1.9u as=0.6072p ps=3.64u w=1.38u l=0.28u
X20 VSS.t0 A.t1 a_172_68# VPW.t1 nfet_03v3 ad=0.1872p pd=1.24u as=0.1872p ps=1.24u w=0.72u l=0.28u
X21 Y.t7 a_172_68# VSS.t7 VPW.t10 nfet_03v3 ad=0.7776p pd=3.6u as=0.1872p ps=1.24u w=0.72u l=0.28u
R0 VSS.n9 VSS.t2 8.67137
R1 VSS.n5 VSS.n4 6.62659
R2 VSS.n8 VSS.n0 6.3905
R3 VSS.n5 VSS.n3 6.38659
R4 VSS.n6 VSS.n2 6.38659
R5 VSS.n7 VSS.n1 6.38659
R6 VSS.n4 VSS.t7 2.2755
R7 VSS.n4 VSS.t5 2.2755
R8 VSS.n3 VSS.t3 2.2755
R9 VSS.n3 VSS.t6 2.2755
R10 VSS.n2 VSS.t8 2.2755
R11 VSS.n2 VSS.t9 2.2755
R12 VSS.n1 VSS.t4 2.2755
R13 VSS.n1 VSS.t10 2.2755
R14 VSS.n0 VSS.t1 2.2755
R15 VSS.n0 VSS.t0 2.2755
R16 VSS.n6 VSS.n5 0.2405
R17 VSS.n7 VSS.n6 0.2405
R18 VSS.n8 VSS.n7 0.2405
R19 VSS.n9 VSS.n8 0.2405
R20 VSS VSS.n9 0.0485
R21 Y.n6 Y.t7 8.8455
R22 Y.n7 Y.n5 6.5705
R23 Y.n8 Y.n3 6.5705
R24 Y.n9 Y.n1 6.5705
R25 Y.n6 Y.t0 4.24021
R26 Y.n7 Y.n4 2.92137
R27 Y.n8 Y.n2 2.92137
R28 Y.n9 Y.n0 2.92137
R29 Y.n5 Y.t6 2.2755
R30 Y.n5 Y.t5 2.2755
R31 Y.n3 Y.t4 2.2755
R32 Y.n3 Y.t3 2.2755
R33 Y.n1 Y.t2 2.2755
R34 Y.n1 Y.t1 2.2755
R35 Y.n4 Y.t13 1.31934
R36 Y.n4 Y.t12 1.31934
R37 Y.n2 Y.t11 1.31934
R38 Y.n2 Y.t10 1.31934
R39 Y.n0 Y.t9 1.31934
R40 Y.n0 Y.t8 1.31934
R41 Y.n7 Y.n6 0.35172
R42 Y.n8 Y.n7 0.35172
R43 Y.n9 Y.n8 0.35172
R44 Y Y.n9 0.0257439
R45 VDD.n9 VDD.t1 12.7019
R46 VDD.n8 VDD.n0 2.8842
R47 VDD.n5 VDD.n4 2.25949
R48 VDD.n7 VDD.n1 2.02731
R49 VDD.n6 VDD.n2 2.01949
R50 VDD.n5 VDD.n3 2.01949
R51 VDD.n0 VDD.t0 1.31934
R52 VDD.n0 VDD.t2 1.31934
R53 VDD.n1 VDD.t3 1.31934
R54 VDD.n1 VDD.t10 1.31934
R55 VDD.n2 VDD.t5 1.31934
R56 VDD.n2 VDD.t4 1.31934
R57 VDD.n3 VDD.t7 1.31934
R58 VDD.n3 VDD.t6 1.31934
R59 VDD.n4 VDD.t9 1.31934
R60 VDD.n4 VDD.t8 1.31934
R61 VDD.n6 VDD.n5 0.2405
R62 VDD.n7 VDD.n6 0.2405
R63 VDD.n8 VDD.n7 0.2405
R64 VDD.n9 VDD.n8 0.2405
R65 VDD VDD.n9 0.0485
R66 A.n0 A.t0 29.8523
R67 A.n0 A.t3 27.2451
R68 A.n1 A.t1 23.7255
R69 A.n2 A.t2 23.7255
R70 A.n1 A.t4 21.6398
R71 A.n2 A.t5 21.6398
R72 A.n1 A.n0 18.0883
R73 A.n2 A.n1 12.9783
R74 A A.n2 10.1444
R75 VNW.t9 VNW.t10 310.079
R76 VNW.t8 VNW.t9 310.079
R77 VNW.t7 VNW.t8 310.079
R78 VNW.t6 VNW.t7 310.079
R79 VNW.t5 VNW.t6 310.079
R80 VNW.t4 VNW.t5 310.079
R81 VNW.t3 VNW.t4 310.079
R82 VNW.t2 VNW.t3 310.079
R83 VNW.t1 VNW.t2 310.079
R84 VNW.t0 VNW.t1 310.079
R85 VNW VNW.t0 259.69
R86 VPW.t9 VPW.t10 1181.82
R87 VPW.t8 VPW.t9 1181.82
R88 VPW.t7 VPW.t8 1181.82
R89 VPW.t6 VPW.t7 1181.82
R90 VPW.t5 VPW.t6 1181.82
R91 VPW.t4 VPW.t5 1181.82
R92 VPW.t3 VPW.t4 1181.82
R93 VPW.t2 VPW.t3 1181.82
R94 VPW.t1 VPW.t2 1181.82
R95 VPW.t0 VPW.t1 1181.82
R96 VPW VPW.t0 989.774
C0 a_172_68# Y 0.46725f
C1 VDD VSS 0.01941f
C2 VDD VNW 0.33024f
C3 VSS VNW 0.00581f
C4 VDD A 0.10686f
C5 a_172_68# VDD 0.82096f
C6 VSS A 0.08998f
C7 VNW A 0.26728f
C8 a_172_68# VSS 0.34068f
C9 a_172_68# VNW 0.75976f
C10 VDD Y 1.19753f
C11 Y VSS 0.36462f
C12 Y VNW 0.12594f
C13 a_172_68# A 0.34026f
C14 VSS VPW 0.68821f
C15 Y VPW 0.16045f
C16 VDD VPW 0.46116f
C17 A VPW 0.46883f
C18 VNW VPW 3.49795f
C19 a_172_68# VPW 1.13776f
C20 VNW.t10 VPW 0.29808f
C21 VNW.t9 VPW 0.10889f
C22 VNW.t8 VPW 0.10889f
C23 VNW.t7 VPW 0.10889f
C24 VNW.t6 VPW 0.10889f
C25 VNW.t5 VPW 0.10889f
C26 VNW.t4 VPW 0.10889f
C27 VNW.t3 VPW 0.10889f
C28 VNW.t2 VPW 0.10889f
C29 VNW.t1 VPW 0.10889f
C30 VNW.t0 VPW 0.10004f
C31 A.t5 VPW 0.06946f
C32 A.t2 VPW 0.0467f
C33 A.t4 VPW 0.06946f
C34 A.t1 VPW 0.0467f
C35 A.t3 VPW 0.0779f
C36 A.t0 VPW 0.05592f
C37 A.n0 VPW 0.10674f
C38 A.n1 VPW 0.15059f
C39 A.n2 VPW 0.15548f
C40 VDD.t1 VPW 0.10152f
C41 VDD.t0 VPW 0.03713f
C42 VDD.t2 VPW 0.03713f
C43 VDD.n0 VPW 0.0789f
C44 VDD.t3 VPW 0.03713f
C45 VDD.t10 VPW 0.03713f
C46 VDD.n1 VPW 0.0816f
C47 VDD.t5 VPW 0.03713f
C48 VDD.t4 VPW 0.03713f
C49 VDD.n2 VPW 0.08129f
C50 VDD.t7 VPW 0.03713f
C51 VDD.t6 VPW 0.03713f
C52 VDD.n3 VPW 0.08129f
C53 VDD.t9 VPW 0.03713f
C54 VDD.t8 VPW 0.03713f
C55 VDD.n4 VPW 0.12145f
C56 VDD.n5 VPW 0.59657f
C57 VDD.n6 VPW 0.25876f
C58 VDD.n7 VPW 0.25988f
C59 VDD.n8 VPW 0.25853f
C60 VDD.n9 VPW 0.16406f
C61 Y.t9 VPW 0.03988f
C62 Y.t8 VPW 0.03988f
C63 Y.n0 VPW 0.08539f
C64 Y.t2 VPW 0.02081f
C65 Y.t1 VPW 0.02081f
C66 Y.n1 VPW 0.0427f
C67 Y.t11 VPW 0.03988f
C68 Y.t10 VPW 0.03988f
C69 Y.n2 VPW 0.08539f
C70 Y.t4 VPW 0.02081f
C71 Y.t3 VPW 0.02081f
C72 Y.n3 VPW 0.0427f
C73 Y.t13 VPW 0.03988f
C74 Y.t12 VPW 0.03988f
C75 Y.n4 VPW 0.08539f
C76 Y.t6 VPW 0.02081f
C77 Y.t5 VPW 0.02081f
C78 Y.n5 VPW 0.0427f
C79 Y.t0 VPW 0.24455f
C80 Y.t7 VPW 0.13457f
C81 Y.n6 VPW 0.32458f
C82 Y.n7 VPW 0.25522f
C83 Y.n8 VPW 0.25522f
C84 Y.n9 VPW 0.18754f
C85 VSS.t2 VPW 0.02399f
C86 VSS.t1 VPW 0.00867f
C87 VSS.t0 VPW 0.00867f
C88 VSS.n0 VPW 0.01742f
C89 VSS.t4 VPW 0.00867f
C90 VSS.t10 VPW 0.00867f
C91 VSS.n1 VPW 0.01745f
C92 VSS.t8 VPW 0.00867f
C93 VSS.t9 VPW 0.00867f
C94 VSS.n2 VPW 0.01744f
C95 VSS.t3 VPW 0.00867f
C96 VSS.t6 VPW 0.00867f
C97 VSS.n3 VPW 0.01744f
C98 VSS.t7 VPW 0.00867f
C99 VSS.t5 VPW 0.00867f
C100 VSS.n4 VPW 0.02293f
C101 VSS.n5 VPW 0.24494f
C102 VSS.n6 VPW 0.0987f
C103 VSS.n7 VPW 0.09934f
C104 VSS.n8 VPW 0.09734f
C105 VSS.n9 VPW 0.06796f
.ends

* NGSPICE file created from gf180mcu_as_sc_mcu7t3v3__dfsrtp_2.ext - technology: gf180mcuD

.subckt gf180mcu_as_sc_mcu7t3v3__dfsrtp_2 VDD VNW VPW VSS CLK Q RN SN D
X0 a_332_68# a_28_68# VDD.t6 VNW.t6 pfet_03v3 ad=0.6693p pd=3.73u as=0.3588p ps=1.9u w=1.38u l=0.28u
X1 a_1430_68# a_1356_395# a_1314_68# VPW.t10 nfet_03v3 ad=0.215p pd=1.43u as=0.15p ps=1.3u w=1u l=0.28u
X2 a_1118_440# a_28_68# a_833_440# VNW.t7 pfet_03v3 ad=0.8211p pd=2.57u as=0.7866p ps=2.52u w=1.38u l=0.285u
X3 VSS.t7 CLK.t0 a_28_68# VPW.t16 nfet_03v3 ad=0.26p pd=1.52u as=0.44p ps=2.88u w=1u l=0.28u
X4 a_1356_395# SN.t1 a_1794_68# VPW.t11 nfet_03v3 ad=0.48p pd=1.96u as=0.405p ps=1.81u w=1u l=0.28u
X5 VSS.t0 a_3062_24# Q.t3 VPW.t5 nfet_03v3 ad=0.615p pd=3.23u as=0.26p ps=1.52u w=1u l=0.28u
X6 VSS.t1 a_3062_24# a_2951_68# VPW.t3 nfet_03v3 ad=0.38p pd=1.76u as=0.2775p ps=1.555u w=1u l=0.28u
X7 a_1794_68# a_833_440# VSS.t5 VPW.t9 nfet_03v3 ad=0.405p pd=1.81u as=0.415p ps=1.83u w=1u l=0.28u
X8 a_2447_68# a_28_68# a_2260_68# VPW.t8 nfet_03v3 ad=1.23p pd=4.46u as=0.3275p ps=1.655u w=1u l=0.28u
X9 a_639_68# D.t1 VDD.t0 VNW.t15 pfet_03v3 ad=0.4554p pd=2.04u as=0.7107p ps=3.79u w=1.38u l=0.285u
X10 VDD.t5 a_3062_24# a_2447_68# VNW.t3 pfet_03v3 ad=0.4554p pd=2.04u as=0.45195p ps=2.035u w=1.38u l=0.28u
X11 VDD.t8 a_833_440# a_1356_395# VNW.t9 pfet_03v3 ad=0.5037p pd=2.11u as=0.6072p ps=3.64u w=1.38u l=0.28u
X12 a_2447_68# a_332_68# a_2260_68# VNW.t2 pfet_03v3 ad=0.8487p pd=3.99u as=0.44505p ps=2.025u w=1.38u l=0.28u
X13 VDD.t9 a_1356_395# a_1118_440# VNW.t10 pfet_03v3 ad=0.3588p pd=1.9u as=0.8211p ps=2.57u w=1.38u l=0.28u
X14 Q.t1 a_3062_24# VDD.t3 VNW.t4 pfet_03v3 ad=0.3588p pd=1.9u as=0.6072p ps=3.64u w=1.38u l=0.28u
X15 Q.t2 a_3062_24# VSS.t2 VPW.t4 nfet_03v3 ad=0.26p pd=1.52u as=0.44p ps=2.88u w=1u l=0.28u
X16 a_2447_68# SN.t2 VDD.t12 VNW.t12 pfet_03v3 ad=0.45195p pd=2.035u as=0.7452p ps=3.84u w=1.38u l=0.28u
X17 VSS.t8 RN.t1 a_1430_68# VPW.t13 nfet_03v3 ad=0.415p pd=1.83u as=0.215p ps=1.43u w=1u l=0.28u
X18 a_639_68# D.t0 VSS.t6 VPW.t15 nfet_03v3 ad=0.62p pd=2.24u as=0.49p ps=2.98u w=1u l=0.28u
X19 a_833_440# a_28_68# a_639_68# VPW.t7 nfet_03v3 ad=0.7875p pd=2.575u as=0.62p ps=2.24u w=1u l=0.28u
X20 a_2260_68# a_28_68# a_1356_395# VNW.t8 pfet_03v3 ad=0.44505p pd=2.025u as=0.89355p ps=2.675u w=1.38u l=0.28u
X21 VDD.t1 a_2260_68# a_3062_24# VNW.t0 pfet_03v3 ad=0.8211p pd=3.95u as=0.4485p ps=2.03u w=1.38u l=0.28u
X22 a_3062_24# RN.t2 VDD.t10 VNW.t14 pfet_03v3 ad=0.4485p pd=2.03u as=0.4554p ps=2.04u w=1.38u l=0.28u
X23 a_833_440# a_332_68# a_639_68# VNW.t1 pfet_03v3 ad=0.7866p pd=2.52u as=0.4554p ps=2.04u w=1.38u l=0.28u
X24 VDD.t4 a_3062_24# Q.t0 VNW.t5 pfet_03v3 ad=0.8487p pd=3.99u as=0.3588p ps=1.9u w=1.38u l=0.28u
X25 a_1118_440# RN.t3 VDD.t11 VNW.t13 pfet_03v3 ad=0.6279p pd=3.67u as=0.3588p ps=1.9u w=1.38u l=0.28u
X26 a_2260_68# a_332_68# a_1356_395# VPW.t2 nfet_03v3 ad=0.3275p pd=1.655u as=0.48p ps=1.96u w=1u l=0.28u
X27 a_3062_24# a_2260_68# a_3326_68# VPW.t0 nfet_03v3 ad=0.505p pd=3.01u as=0.325p ps=1.65u w=1u l=0.28u
X28 a_1356_395# SN.t3 VDD.t2 VNW.t11 pfet_03v3 ad=0.89355p pd=2.675u as=0.5037p ps=2.11u w=1.38u l=0.28u
X29 a_1314_68# a_332_68# a_833_440# VPW.t1 nfet_03v3 ad=0.15p pd=1.3u as=0.7875p ps=2.575u w=1u l=0.28u
X30 a_2951_68# SN.t0 a_2447_68# VPW.t12 nfet_03v3 ad=0.2775p pd=1.555u as=0.61p ps=3.22u w=1u l=0.28u
X31 VDD.t7 CLK.t1 a_28_68# VNW.t16 pfet_03v3 ad=0.3588p pd=1.9u as=0.6072p ps=3.64u w=1.38u l=0.28u
X32 a_3326_68# RN.t0 VSS.t4 VPW.t14 nfet_03v3 ad=0.325p pd=1.65u as=0.38p ps=1.76u w=1u l=0.28u
X33 a_332_68# a_28_68# VSS.t3 VPW.t6 nfet_03v3 ad=0.485p pd=2.97u as=0.26p ps=1.52u w=1u l=0.28u
R0 VSS.n6 VSS.t6 10.5009
R1 VSS.n7 VSS.n0 6.38659
R2 VSS.n5 VSS.n1 6.35627
R3 VSS.n4 VSS.n2 6.34821
R4 VSS.n3 VSS.t0 5.2398
R5 VSS.n3 VSS.t2 4.9998
R6 VSS.n1 VSS.t8 3.2135
R7 VSS.n2 VSS.t1 3.1505
R8 VSS.n1 VSS.t5 2.0165
R9 VSS.n2 VSS.t4 1.6385
R10 VSS.n0 VSS.t3 1.6385
R11 VSS.n0 VSS.t7 1.6385
R12 VSS.n5 VSS.n4 1.16075
R13 VSS.n6 VSS.n5 0.86525
R14 VSS.n4 VSS.n3 0.3785
R15 VSS.n7 VSS.n6 0.22325
R16 VSS VSS.n7 0.1685
R17 Q.n2 Q.n1 6.3005
R18 Q.n2 Q.n0 2.9919
R19 Q.n1 Q.t3 1.6385
R20 Q.n1 Q.t2 1.6385
R21 Q.n0 Q.t0 1.31934
R22 Q.n0 Q.t1 1.31934
R23 Q Q.n2 0.0842209
R24 VDD.n10 VDD.t0 12.2186
R25 VDD.n7 VDD.t12 11.772
R26 VDD.n6 VDD.n3 5.28854
R27 VDD.n11 VDD.n0 5.28659
R28 VDD.n8 VDD.n2 5.25475
R29 VDD.n9 VDD.n1 5.24764
R30 VDD.n5 VDD.t1 4.12456
R31 VDD.n4 VDD.t4 3.57833
R32 VDD.n4 VDD.t3 3.33833
R33 VDD.n2 VDD.t2 1.9534
R34 VDD.n3 VDD.t5 1.80122
R35 VDD.n2 VDD.t8 1.7505
R36 VDD.n3 VDD.t10 1.5476
R37 VDD.n0 VDD.t6 1.31934
R38 VDD.n0 VDD.t7 1.31934
R39 VDD.n1 VDD.t11 1.31934
R40 VDD.n1 VDD.t9 1.31934
R41 VDD.n10 VDD.n9 0.70925
R42 VDD.n8 VDD.n7 0.6815
R43 VDD.n9 VDD.n8 0.35
R44 VDD.n6 VDD.n5 0.29
R45 VDD.n7 VDD.n6 0.27725
R46 VDD.n11 VDD.n10 0.22325
R47 VDD VDD.n11 0.1685
R48 VDD.n5 VDD.n4 0.098
R49 SN.n1 SN.t1 27.9043
R50 SN.n0 SN.t2 27.053
R51 SN.n1 SN.t3 25.4201
R52 SN.n0 SN.t0 23.9245
R53 SN.n2 SN.n1 18.8666
R54 SN.n2 SN.n0 8.07479
R55 SN SN.n2 0.0195476
R56 RN.n1 RN.t2 32.0684
R57 RN.n0 RN.t3 30.5844
R58 RN.n0 RN.t1 20.6773
R59 RN.n1 RN.t0 19.2934
R60 RN.n2 RN.n0 11.47
R61 RN.n2 RN.n1 8.08509
R62 RN RN.n2 0.0160639
R63 D.n0 D.t1 26.7031
R64 D.n0 D.t0 24.2469
R65 D D.n0 8.05759
R66 CLK.n0 CLK.t1 27.839
R67 CLK.n0 CLK.t0 23.4648
R68 CLK CLK.n0 8.10909
R69 VNW.t2 VNW.t12 748.062
R70 VNW.t0 VNW.t4 622.093
R71 VNW.t11 VNW.t8 610.466
R72 VNW.t6 VNW.t15 604.652
R73 VNW.t7 VNW.t10 571.706
R74 VNW.t13 VNW.t9 563.953
R75 VNW.t1 VNW.t7 550.389
R76 VNW.t9 VNW.t11 391.474
R77 VNW.t15 VNW.t1 366.279
R78 VNW.t3 VNW.t14 364.341
R79 VNW.t12 VNW.t3 362.404
R80 VNW.t14 VNW.t0 360.466
R81 VNW.t8 VNW.t2 358.527
R82 VNW.t4 VNW.t5 310.079
R83 VNW.t10 VNW.t13 310.079
R84 VNW.t16 VNW.t6 310.079
R85 VNW VNW.t16 259.69
R86 VPW.t8 VPW.t12 3722.73
R87 VPW.t7 VPW.t1 2740.34
R88 VPW.t0 VPW.t4 2371.02
R89 VPW.t6 VPW.t15 2267.61
R90 VPW.t15 VPW.t7 2245.45
R91 VPW.t11 VPW.t2 1831.82
R92 VPW.t13 VPW.t9 1639.77
R93 VPW.t9 VPW.t11 1610.23
R94 VPW.t3 VPW.t14 1536.36
R95 VPW.t2 VPW.t8 1381.25
R96 VPW.t14 VPW.t0 1373.86
R97 VPW.t12 VPW.t3 1233.52
R98 VPW.t4 VPW.t5 1181.82
R99 VPW.t16 VPW.t6 1181.82
R100 VPW.t10 VPW.t13 1048.86
R101 VPW VPW.t16 989.774
R102 VPW.t1 VPW.t10 856.818
C0 a_332_68# VDD 0.03566f
C1 a_2447_68# VDD 0.0192f
C2 a_28_68# a_1356_395# 0.55779f
C3 RN SN 0.05306f
C4 VSS a_1356_395# 0.01873f
C5 a_3062_24# RN 0.47247f
C6 a_28_68# a_833_440# 1.06585f
C7 a_1314_68# RN 0
C8 VSS a_833_440# 0.02462f
C9 RN a_2951_68# 0.01198f
C10 VNW a_1356_395# 0.11791f
C11 a_3062_24# SN 0.03078f
C12 a_2260_68# a_332_68# 0.36391f
C13 VNW a_833_440# 0.1494f
C14 a_2447_68# a_2260_68# 0.30124f
C15 a_28_68# a_1118_440# 0.10144f
C16 a_1356_395# VDD 0.20977f
C17 RN a_1430_68# 0.00133f
C18 a_833_440# VDD 0.05715f
C19 VNW a_1118_440# 0.00622f
C20 VSS a_1794_68# 0.00999f
C21 a_1118_440# VDD 0.28997f
C22 CLK a_332_68# 0
C23 a_28_68# D 0.22209f
C24 VSS D 0.01356f
C25 a_639_68# SN 0
C26 RN a_332_68# 0.22842f
C27 a_2260_68# a_1356_395# 0.00821f
C28 a_2447_68# RN 0.4461f
C29 VNW D 0.09151f
C30 a_2260_68# a_833_440# 0
C31 a_332_68# SN 0.14652f
C32 a_3062_24# a_332_68# 0
C33 a_2447_68# SN 0.68318f
C34 a_2447_68# a_3062_24# 0.20961f
C35 D VDD 0.01931f
C36 a_1314_68# a_332_68# 0.00893f
C37 a_2951_68# a_332_68# 0
C38 a_2447_68# a_2951_68# 0.007f
C39 a_2260_68# a_1118_440# 0
C40 VSS Q 0.27326f
C41 CLK a_1356_395# 0
C42 VSS a_28_68# 0.15978f
C43 Q VNW 0.0111f
C44 a_1430_68# a_332_68# 0.01375f
C45 a_28_68# VNW 0.36711f
C46 Q VDD 0.35047f
C47 RN a_1356_395# 0.23981f
C48 VSS a_3326_68# 0.01462f
C49 VSS VNW 0.00638f
C50 a_833_440# RN 0.25178f
C51 a_639_68# a_332_68# 0.39955f
C52 a_28_68# VDD 1.02009f
C53 SN a_1356_395# 0.6503f
C54 VSS VDD 0.03274f
C55 a_833_440# SN 0.02763f
C56 a_1314_68# a_1356_395# 0
C57 a_1118_440# RN 0.01214f
C58 a_1314_68# a_833_440# 0
C59 VNW VDD 0.53305f
C60 a_2447_68# a_332_68# 0.23693f
C61 a_1118_440# SN 0.00124f
C62 a_1430_68# a_1356_395# 0
C63 a_2260_68# Q 0.00603f
C64 a_1794_68# RN 0.02308f
C65 a_833_440# a_1430_68# 0
C66 a_2260_68# a_28_68# 0.23176f
C67 VSS a_2260_68# 0.01977f
C68 a_639_68# a_1356_395# 0
C69 a_833_440# a_639_68# 0.00479f
C70 a_2260_68# VNW 0.1369f
C71 a_332_68# a_1356_395# 0.6715f
C72 a_2260_68# VDD 1.20142f
C73 a_833_440# a_332_68# 0.46193f
C74 CLK a_28_68# 0.33055f
C75 VSS CLK 0.01737f
C76 a_28_68# RN 0.02428f
C77 CLK VNW 0.08108f
C78 a_1118_440# a_332_68# 0.00184f
C79 Q SN 0
C80 a_3062_24# Q 0.12887f
C81 VSS RN 1.70677f
C82 a_28_68# SN 0.25896f
C83 CLK VDD 0.01655f
C84 RN a_3326_68# 0.00646f
C85 D a_639_68# 0.26342f
C86 VNW RN 0.16643f
C87 VSS SN 0.02494f
C88 VSS a_3062_24# 0.28272f
C89 a_1794_68# a_332_68# 0.00537f
C90 a_1314_68# a_28_68# 0.00122f
C91 VSS a_1314_68# 0.00446f
C92 VSS a_2951_68# 0.00326f
C93 a_3062_24# a_3326_68# 0.01424f
C94 VNW SN 0.21951f
C95 RN VDD 0.03335f
C96 a_3062_24# VNW 0.3419f
C97 a_833_440# a_1356_395# 0.45288f
C98 D a_332_68# 0.40041f
C99 SN VDD 0.19441f
C100 a_3062_24# VDD 0.19705f
C101 VSS a_1430_68# 0.00689f
C102 a_1118_440# a_1356_395# 0.05062f
C103 a_1118_440# a_833_440# 0.55261f
C104 a_28_68# a_639_68# 0.16664f
C105 VSS a_639_68# 0.00836f
C106 Q a_332_68# 0
C107 a_1794_68# a_1356_395# 0.00116f
C108 a_2260_68# RN 0.21472f
C109 a_1794_68# a_833_440# 0
C110 VNW a_639_68# 0.01711f
C111 a_28_68# a_332_68# 0.59139f
C112 VSS a_332_68# 1.12871f
C113 a_2260_68# SN 0.4342f
C114 a_3062_24# a_2260_68# 0.75367f
C115 a_2447_68# a_28_68# 0
C116 VSS a_2447_68# 0.00957f
C117 D a_1356_395# 0
C118 a_639_68# VDD 0.00587f
C119 a_2260_68# a_2951_68# 0
C120 a_332_68# a_3326_68# 0
C121 VNW a_332_68# 0.22273f
C122 a_2447_68# VNW 0.0298f
C123 VSS VPW 1.37752f
C124 Q VPW 0.05435f
C125 VDD VPW 0.93994f
C126 SN VPW 0.36005f
C127 RN VPW 0.25077f
C128 D VPW 0.64661f
C129 CLK VPW 0.25482f
C130 VNW VPW 6.77552f
C131 a_2447_68# VPW 0.02958f
C132 a_639_68# VPW 0.00695f
C133 a_2260_68# VPW 0.10231f
C134 a_3062_24# VPW 0.40183f
C135 a_833_440# VPW 0.13927f
C136 a_1356_395# VPW 0.11123f
C137 a_332_68# VPW 0.44192f
C138 a_28_68# VPW 0.62256f
C139 VNW.t5 VPW 0.19969f
C140 VNW.t4 VPW 0.1392f
C141 VNW.t0 VPW 0.14673f
C142 VNW.t14 VPW 0.10824f
C143 VNW.t3 VPW 0.10853f
C144 VNW.t12 VPW 0.16583f
C145 VNW.t2 VPW 0.16525f
C146 VNW.t8 VPW 0.1447f
C147 VNW.t11 VPW 0.14962f
C148 VNW.t9 VPW 0.14268f
C149 VNW.t13 VPW 0.13052f
C150 VNW.t10 VPW 0.13168f
C151 VNW.t7 VPW 0.16757f
C152 VNW.t1 VPW 0.13689f
C153 VNW.t15 VPW 0.14499f
C154 VNW.t6 VPW 0.1366f
C155 VNW.t16 VPW 0.08508f
C156 CLK.t1 VPW 0.10969f
C157 CLK.t0 VPW 0.08001f
C158 CLK.n0 VPW 0.12679f
C159 D.t1 VPW 0.1625f
C160 D.t0 VPW 0.12039f
C161 D.n0 VPW 0.18802f
C162 RN.t3 VPW 0.25115f
C163 RN.t1 VPW 0.16195f
C164 RN.n0 VPW 0.56812f
C165 RN.t2 VPW 0.25777f
C166 RN.t0 VPW 0.15573f
C167 RN.n1 VPW 0.27686f
C168 RN.n2 VPW 2.18893f
C169 SN.t2 VPW 0.17012f
C170 SN.t0 VPW 0.12757f
C171 SN.n0 VPW 0.2055f
C172 SN.t3 VPW 0.16391f
C173 SN.t1 VPW 0.14459f
C174 SN.n1 VPW 0.62975f
C175 SN.n2 VPW 1.22608f
C176 VDD.t6 VPW 0.03573f
C177 VDD.t7 VPW 0.03573f
C178 VDD.n0 VPW 0.07167f
C179 VDD.t0 VPW 0.11632f
C180 VDD.t11 VPW 0.03573f
C181 VDD.t9 VPW 0.03573f
C182 VDD.n1 VPW 0.07163f
C183 VDD.t2 VPW 0.05291f
C184 VDD.t8 VPW 0.04741f
C185 VDD.n2 VPW 0.10049f
C186 VDD.t12 VPW 0.12246f
C187 VDD.t10 VPW 0.04191f
C188 VDD.t5 VPW 0.04878f
C189 VDD.n3 VPW 0.09092f
C190 VDD.t1 VPW 0.11269f
C191 VDD.t3 VPW 0.09162f
C192 VDD.t4 VPW 0.13886f
C193 VDD.n4 VPW 0.48378f
C194 VDD.n5 VPW 0.27255f
C195 VDD.n6 VPW 0.2441f
C196 VDD.n7 VPW 0.42667f
C197 VDD.n8 VPW 0.43465f
C198 VDD.n9 VPW 0.44937f
C199 VDD.n10 VPW 0.41412f
C200 VDD.n11 VPW 0.1733f
C201 Q.t0 VPW 0.056f
C202 Q.t1 VPW 0.056f
C203 Q.n0 VPW 0.13878f
C204 Q.t3 VPW 0.04058f
C205 Q.t2 VPW 0.04058f
C206 Q.n1 VPW 0.08116f
C207 Q.n2 VPW 0.33025f
C208 VSS.t3 VPW 0.02876f
C209 VSS.t7 VPW 0.02876f
C210 VSS.n0 VPW 0.05771f
C211 VSS.t6 VPW 0.09408f
C212 VSS.t5 VPW 0.0354f
C213 VSS.t8 VPW 0.05642f
C214 VSS.n1 VPW 0.09197f
C215 VSS.t4 VPW 0.02876f
C216 VSS.t1 VPW 0.05531f
C217 VSS.n2 VPW 0.08423f
C218 VSS.t2 VPW 0.07664f
C219 VSS.t0 VPW 0.11459f
C220 VSS.n3 VPW 0.59821f
C221 VSS.n4 VPW 0.71124f
C222 VSS.n5 VPW 0.92217f
C223 VSS.n6 VPW 0.51536f
C224 VSS.n7 VPW 0.19255f
.ends

* NGSPICE file created from gf180mcu_as_sc_mcu7t3v3__dfxtn_2.ext - technology: gf180mcuD

.subckt gf180mcu_as_sc_mcu7t3v3__dfxtn_2 VDD VNW VPW VSS CLK D Q
X0 a_1709_68# a_332_68# a_1315_24# VNW.t7 pfet_03v3 ad=0.8418p pd=2.6u as=0.83145p ps=2.585u w=1.38u l=0.28u
X1 a_853_68# D.t0 a_629_68# VPW.t1 nfet_03v3 ad=0.875p pd=2.75u as=0.42p ps=1.84u w=1u l=0.28u
X2 VSS.t5 a_1315_24# a_1259_68# VPW.t5 nfet_03v3 ad=0.26p pd=1.52u as=0.14p ps=1.28u w=1u l=0.28u
X3 a_1709_68# a_28_68# a_1315_24# VPW.t10 nfet_03v3 ad=0.625p pd=2.25u as=0.305p ps=1.61u w=1u l=0.28u
X4 a_2015_68# a_332_68# a_1709_68# VPW.t7 nfet_03v3 ad=0.43p pd=1.86u as=0.625p ps=2.25u w=1u l=0.28u
X5 a_332_68# a_28_68# VDD.t7 VNW.t8 pfet_03v3 ad=0.6693p pd=3.73u as=0.3588p ps=1.9u w=1.38u l=0.28u
X6 VSS.t1 CLK.t0 a_28_68# VPW.t12 nfet_03v3 ad=0.26p pd=1.52u as=0.44p ps=2.88u w=1u l=0.28u
X7 a_1259_68# a_28_68# a_853_68# VPW.t9 nfet_03v3 ad=0.14p pd=1.28u as=0.875p ps=2.75u w=1u l=0.28u
X8 VDD.t1 a_2187_24# a_2128_440# VNW.t2 pfet_03v3 ad=0.3588p pd=1.9u as=0.20355p ps=1.675u w=1.38u l=0.28u
X9 a_2187_24# a_1709_68# VSS.t0 VPW.t0 nfet_03v3 ad=0.55p pd=3.1u as=0.26p ps=1.52u w=1u l=0.28u
X10 VDD.t5 a_1315_24# a_1064_440# VNW.t5 pfet_03v3 ad=0.3588p pd=1.9u as=0.86595p ps=2.635u w=1.38u l=0.28u
X11 a_735_440# a_28_68# VDD.t6 VNW.t9 pfet_03v3 ad=0.2139p pd=1.69u as=1.3317p ps=4.69u w=1.38u l=0.285u
X12 a_853_68# D.t1 a_735_440# VNW.t1 pfet_03v3 ad=0.5313p pd=2.15u as=0.2139p ps=1.69u w=1.38u l=0.28u
X13 a_629_68# a_332_68# VSS.t6 VPW.t6 nfet_03v3 ad=0.42p pd=1.84u as=0.44p ps=2.88u w=1u l=0.28u
X14 VSS.t3 a_2187_24# Q.t3 VPW.t4 nfet_03v3 ad=0.615p pd=3.23u as=0.26p ps=1.52u w=1u l=0.28u
X15 VSS.t2 a_2187_24# a_2015_68# VPW.t2 nfet_03v3 ad=0.26p pd=1.52u as=0.43p ps=1.86u w=1u l=0.28u
X16 a_1315_24# a_853_68# VDD.t8 VNW.t11 pfet_03v3 ad=0.83145p pd=2.585u as=0.3588p ps=1.9u w=1.38u l=0.28u
X17 Q.t0 a_2187_24# VDD.t2 VNW.t3 pfet_03v3 ad=0.3588p pd=1.9u as=0.6072p ps=3.64u w=1.38u l=0.28u
X18 a_2187_24# a_1709_68# VDD.t0 VNW.t0 pfet_03v3 ad=0.759p pd=3.86u as=0.3588p ps=1.9u w=1.38u l=0.28u
X19 Q.t2 a_2187_24# VSS.t4 VPW.t3 nfet_03v3 ad=0.26p pd=1.52u as=0.44p ps=2.88u w=1u l=0.28u
X20 a_1064_440# a_332_68# a_853_68# VNW.t6 pfet_03v3 ad=0.86595p pd=2.635u as=0.5313p ps=2.15u w=1.38u l=0.285u
X21 a_2128_440# a_28_68# a_1709_68# VNW.t10 pfet_03v3 ad=0.20355p pd=1.675u as=0.8418p ps=2.6u w=1.38u l=0.28u
X22 a_1315_24# a_853_68# VSS.t8 VPW.t11 nfet_03v3 ad=0.305p pd=1.61u as=0.26p ps=1.52u w=1u l=0.28u
X23 VDD.t3 a_2187_24# Q.t1 VNW.t4 pfet_03v3 ad=0.8487p pd=3.99u as=0.3588p ps=1.9u w=1.38u l=0.28u
X24 VDD.t4 CLK.t1 a_28_68# VNW.t12 pfet_03v3 ad=0.3588p pd=1.9u as=0.6072p ps=3.64u w=1.38u l=0.28u
X25 a_332_68# a_28_68# VSS.t7 VPW.t8 nfet_03v3 ad=0.485p pd=2.97u as=0.26p ps=1.52u w=1u l=0.28u
R0 VSS.n6 VSS.t6 10.9684
R1 VSS.n4 VSS.n2 6.38659
R2 VSS.n5 VSS.n1 6.38659
R3 VSS.n7 VSS.n0 6.38659
R4 VSS.n3 VSS.t3 5.2398
R5 VSS.n3 VSS.t4 4.9998
R6 VSS.n2 VSS.t0 1.6385
R7 VSS.n2 VSS.t2 1.6385
R8 VSS.n1 VSS.t8 1.6385
R9 VSS.n1 VSS.t5 1.6385
R10 VSS.n0 VSS.t7 1.6385
R11 VSS.n0 VSS.t1 1.6385
R12 VSS.n6 VSS.n5 0.677
R13 VSS.n5 VSS.n4 0.6545
R14 VSS.n4 VSS.n3 0.233
R15 VSS.n7 VSS.n6 0.22325
R16 VSS VSS.n7 0.1685
R17 Q.n2 Q.n1 6.3005
R18 Q.n2 Q.n0 5.45585
R19 Q.n1 Q.t3 1.6385
R20 Q.n1 Q.t2 1.6385
R21 Q.n0 Q.t1 1.31934
R22 Q.n0 Q.t0 1.31934
R23 Q Q.n2 0.0360814
R24 VDD.n6 VDD.t6 9.26847
R25 VDD.n7 VDD.n0 5.28659
R26 VDD.n5 VDD.n1 5.28659
R27 VDD.n4 VDD.n2 5.28659
R28 VDD.n3 VDD.t3 3.57833
R29 VDD.n3 VDD.t2 3.33833
R30 VDD.n0 VDD.t7 1.31934
R31 VDD.n0 VDD.t4 1.31934
R32 VDD.n1 VDD.t8 1.31934
R33 VDD.n1 VDD.t5 1.31934
R34 VDD.n2 VDD.t0 1.31934
R35 VDD.n2 VDD.t1 1.31934
R36 VDD.n6 VDD.n5 0.677
R37 VDD.n5 VDD.n4 0.6545
R38 VDD.n4 VDD.n3 0.233
R39 VDD.n7 VDD.n6 0.22325
R40 VDD VDD.n7 0.1685
R41 D.n0 D.t1 27.1148
R42 D.n0 D.t0 24.2469
R43 D D.n0 8.01296
R44 CLK.n0 CLK.t1 27.839
R45 CLK.n0 CLK.t0 23.4648
R46 CLK CLK.n0 8.10909
R47 VNW.t8 VNW.t9 779.071
R48 VNW.t0 VNW.t3 600.775
R49 VNW.t6 VNW.t5 596.899
R50 VNW.t7 VNW.t10 581.395
R51 VNW.t11 VNW.t7 575.582
R52 VNW.t1 VNW.t6 406.978
R53 VNW.t3 VNW.t4 310.079
R54 VNW.t2 VNW.t0 310.079
R55 VNW.t5 VNW.t11 310.079
R56 VNW.t12 VNW.t8 310.079
R57 VNW VNW.t12 259.69
R58 VNW.t9 VNW.t1 230.62
R59 VNW.t10 VNW.t2 222.869
R60 VPW.t1 VPW.t9 2998.86
R61 VPW.t0 VPW.t3 2289.77
R62 VPW.t10 VPW.t7 2260.23
R63 VPW.t8 VPW.t6 2193.75
R64 VPW.t7 VPW.t2 1684.09
R65 VPW.t6 VPW.t1 1654.55
R66 VPW.t11 VPW.t10 1314.77
R67 VPW.t3 VPW.t4 1181.82
R68 VPW.t2 VPW.t0 1181.82
R69 VPW.t5 VPW.t11 1181.82
R70 VPW.t12 VPW.t8 1181.82
R71 VPW VPW.t12 989.774
R72 VPW.t9 VPW.t5 827.274
C0 a_28_68# a_1259_68# 0.00617f
C1 VDD a_2015_68# 0
C2 VDD a_1709_68# 0.03802f
C3 a_1315_24# VDD 0.05435f
C4 VSS a_2015_68# 0.01409f
C5 VSS a_1709_68# 0.27865f
C6 VSS a_629_68# 0.00961f
C7 a_1315_24# VSS 0.15044f
C8 a_28_68# a_2128_440# 0.00508f
C9 VDD VNW 0.41669f
C10 VDD Q 0.12135f
C11 VSS VNW 0.01173f
C12 VNW CLK 0.08108f
C13 Q VSS 0.1221f
C14 VDD a_853_68# 0.0886f
C15 a_853_68# VSS 0.03189f
C16 a_1259_68# a_1709_68# 0
C17 a_332_68# a_2128_440# 0.00148f
C18 a_1315_24# a_1259_68# 0.00162f
C19 a_2187_24# a_2128_440# 0.00346f
C20 a_2128_440# a_1709_68# 0.00332f
C21 a_735_440# VDD 0.00188f
C22 a_28_68# D 0.19063f
C23 a_853_68# a_1259_68# 0.00239f
C24 a_28_68# a_332_68# 1.12475f
C25 a_28_68# a_2187_24# 0.17343f
C26 VDD a_1064_440# 0.01239f
C27 a_28_68# a_2015_68# 0.00161f
C28 a_28_68# a_1709_68# 0.2078f
C29 a_28_68# a_629_68# 0.02331f
C30 a_1064_440# VSS 0
C31 a_1315_24# a_28_68# 0.4611f
C32 a_332_68# D 0.17612f
C33 a_332_68# a_2187_24# 0.01436f
C34 a_28_68# VNW 0.43691f
C35 a_332_68# a_1709_68# 0.16622f
C36 a_2187_24# a_1709_68# 0.44509f
C37 a_332_68# a_629_68# 0.00262f
C38 a_1315_24# a_332_68# 0.04313f
C39 a_28_68# a_853_68# 0.55009f
C40 VNW D 0.0725f
C41 a_2015_68# a_1709_68# 0.02071f
C42 a_332_68# VNW 0.2727f
C43 VNW a_2187_24# 0.33165f
C44 a_1315_24# a_1709_68# 0.02396f
C45 a_332_68# Q 0.00108f
C46 Q a_2187_24# 0.08051f
C47 a_853_68# D 0.22443f
C48 VNW a_1709_68# 0.09488f
C49 a_853_68# a_332_68# 0.66932f
C50 a_1315_24# VNW 0.08201f
C51 a_735_440# a_28_68# 0.00257f
C52 VDD VSS 0.0613f
C53 VDD CLK 0.01655f
C54 a_853_68# a_1709_68# 0
C55 a_853_68# a_629_68# 0.00143f
C56 a_1315_24# a_853_68# 0.37583f
C57 VSS CLK 0.01737f
C58 Q VNW 0.01013f
C59 a_735_440# D 0.00376f
C60 a_28_68# a_1064_440# 0.00441f
C61 a_853_68# VNW 0.10526f
C62 a_735_440# a_332_68# 0.01216f
C63 VSS a_1259_68# 0.00587f
C64 a_1064_440# a_332_68# 0.04755f
C65 VDD a_2128_440# 0.00747f
C66 a_1315_24# a_1064_440# 0
C67 a_28_68# VDD 0.47373f
C68 a_1064_440# a_853_68# 0.0237f
C69 a_28_68# VSS 0.8643f
C70 a_28_68# CLK 0.3301f
C71 VDD D 0.01488f
C72 VSS D 0.01048f
C73 VDD a_332_68# 1.09573f
C74 VDD a_2187_24# 0.38f
C75 a_332_68# VSS 0.16089f
C76 VSS a_2187_24# 0.16699f
C77 a_332_68# CLK 0.0012f
C78 VSS VPW 1.03633f
C79 Q VPW 0.03434f
C80 VDD VPW 0.72806f
C81 D VPW 0.38299f
C82 CLK VPW 0.25478f
C83 VNW VPW 5.04511f
C84 a_1709_68# VPW 0.11369f
C85 a_2187_24# VPW 0.37813f
C86 a_853_68# VPW 0.11239f
C87 a_1315_24# VPW 0.09256f
C88 a_332_68# VPW 0.43778f
C89 a_28_68# VPW 0.53184f
C90 VNW.t4 VPW 0.20678f
C91 VNW.t3 VPW 0.14085f
C92 VNW.t0 VPW 0.14085f
C93 VNW.t2 VPW 0.08241f
C94 VNW.t10 VPW 0.12437f
C95 VNW.t7 VPW 0.17891f
C96 VNW.t11 VPW 0.13695f
C97 VNW.t5 VPW 0.14025f
C98 VNW.t6 VPW 0.15523f
C99 VNW.t1 VPW 0.09859f
C100 VNW.t9 VPW 0.15613f
C101 VNW.t8 VPW 0.16842f
C102 VNW.t12 VPW 0.08811f
C103 CLK.t1 VPW 0.10965f
C104 CLK.t0 VPW 0.07998f
C105 CLK.n0 VPW 0.12674f
C106 D.t1 VPW 0.13889f
C107 D.t0 VPW 0.10483f
C108 D.n0 VPW 0.16137f
C109 VDD.t7 VPW 0.03318f
C110 VDD.t4 VPW 0.03318f
C111 VDD.n0 VPW 0.06655f
C112 VDD.t6 VPW 0.18362f
C113 VDD.t8 VPW 0.03318f
C114 VDD.t5 VPW 0.03318f
C115 VDD.n1 VPW 0.06655f
C116 VDD.t0 VPW 0.03318f
C117 VDD.t1 VPW 0.03318f
C118 VDD.n2 VPW 0.06655f
C119 VDD.t2 VPW 0.08507f
C120 VDD.t3 VPW 0.12895f
C121 VDD.n3 VPW 0.49917f
C122 VDD.n4 VPW 0.34429f
C123 VDD.n5 VPW 0.50851f
C124 VDD.n6 VPW 0.41186f
C125 VDD.n7 VPW 0.16092f
C126 Q.t1 VPW 0.03151f
C127 Q.t0 VPW 0.03151f
C128 Q.n0 VPW 0.06577f
C129 Q.t3 VPW 0.02283f
C130 Q.t2 VPW 0.02283f
C131 Q.n1 VPW 0.04566f
C132 Q.n2 VPW 0.10864f
C133 VSS.t7 VPW 0.01908f
C134 VSS.t1 VPW 0.01908f
C135 VSS.n0 VPW 0.03829f
C136 VSS.t6 VPW 0.05548f
C137 VSS.t8 VPW 0.01908f
C138 VSS.t5 VPW 0.01908f
C139 VSS.n1 VPW 0.03829f
C140 VSS.t0 VPW 0.01908f
C141 VSS.t2 VPW 0.01908f
C142 VSS.n2 VPW 0.03829f
C143 VSS.t4 VPW 0.05084f
C144 VSS.t3 VPW 0.07602f
C145 VSS.n3 VPW 0.35412f
C146 VSS.n4 VPW 0.27325f
C147 VSS.n5 VPW 0.40357f
C148 VSS.n6 VPW 0.28621f
C149 VSS.n7 VPW 0.12773f
.ends

* NGSPICE file created from gf180mcu_as_sc_mcu7t3v3__dfxtp_2.ext - technology: gf180mcuD

.subckt gf180mcu_as_sc_mcu7t3v3__dfxtp_2 VDD VNW VPW VSS CLK D Q
X0 a_1709_68# a_28_68# a_1315_24# VNW.t11 pfet_03v3 ad=0.8418p pd=2.6u as=0.83145p ps=2.585u w=1.38u l=0.28u
X1 a_853_68# D.t0 a_629_68# VPW.t1 nfet_03v3 ad=0.875p pd=2.75u as=0.42p ps=1.84u w=1u l=0.28u
X2 VSS.t6 a_1315_24# a_1259_68# VPW.t6 nfet_03v3 ad=0.26p pd=1.52u as=0.14p ps=1.28u w=1u l=0.28u
X3 a_1709_68# a_332_68# a_1315_24# VPW.t8 nfet_03v3 ad=0.625p pd=2.25u as=0.305p ps=1.61u w=1u l=0.28u
X4 a_2015_68# a_28_68# a_1709_68# VPW.t11 nfet_03v3 ad=0.43p pd=1.86u as=0.625p ps=2.25u w=1u l=0.28u
X5 a_332_68# a_28_68# VDD.t8 VNW.t9 pfet_03v3 ad=0.6693p pd=3.73u as=0.3588p ps=1.9u w=1.38u l=0.28u
X6 VSS.t1 CLK.t0 a_28_68# VPW.t12 nfet_03v3 ad=0.26p pd=1.52u as=0.44p ps=2.88u w=1u l=0.28u
X7 a_1259_68# a_332_68# a_853_68# VPW.t7 nfet_03v3 ad=0.14p pd=1.28u as=0.875p ps=2.75u w=1u l=0.28u
X8 VDD.t3 a_2187_24# a_2128_440# VNW.t3 pfet_03v3 ad=0.3588p pd=1.9u as=0.20355p ps=1.675u w=1.38u l=0.28u
X9 a_2187_24# a_1709_68# VSS.t0 VPW.t0 nfet_03v3 ad=0.55p pd=3.1u as=0.26p ps=1.52u w=1u l=0.28u
X10 VDD.t6 a_1315_24# a_1064_440# VNW.t6 pfet_03v3 ad=0.3588p pd=1.9u as=0.86595p ps=2.635u w=1.38u l=0.28u
X11 a_735_440# a_332_68# VDD.t7 VNW.t7 pfet_03v3 ad=0.2139p pd=1.69u as=1.3317p ps=4.69u w=1.38u l=0.285u
X12 a_853_68# D.t1 a_735_440# VNW.t1 pfet_03v3 ad=0.5313p pd=2.15u as=0.2139p ps=1.69u w=1.38u l=0.28u
X13 a_629_68# a_28_68# VSS.t7 VPW.t10 nfet_03v3 ad=0.42p pd=1.84u as=0.44p ps=2.88u w=1u l=0.28u
X14 VSS.t5 a_2187_24# Q.t2 VPW.t5 nfet_03v3 ad=0.615p pd=3.23u as=0.26p ps=1.52u w=1u l=0.28u
X15 VSS.t3 a_2187_24# a_2015_68# VPW.t3 nfet_03v3 ad=0.26p pd=1.52u as=0.43p ps=1.86u w=1u l=0.28u
X16 a_1315_24# a_853_68# VDD.t2 VNW.t2 pfet_03v3 ad=0.83145p pd=2.585u as=0.3588p ps=1.9u w=1.38u l=0.28u
X17 Q.t0 a_2187_24# VDD.t4 VNW.t4 pfet_03v3 ad=0.3588p pd=1.9u as=0.6072p ps=3.64u w=1.38u l=0.28u
X18 a_2187_24# a_1709_68# VDD.t0 VNW.t0 pfet_03v3 ad=0.759p pd=3.86u as=0.3588p ps=1.9u w=1.38u l=0.28u
X19 Q.t1 a_2187_24# VSS.t4 VPW.t4 nfet_03v3 ad=0.26p pd=1.52u as=0.44p ps=2.88u w=1u l=0.28u
X20 a_1064_440# a_28_68# a_853_68# VNW.t10 pfet_03v3 ad=0.86595p pd=2.635u as=0.5313p ps=2.15u w=1.38u l=0.285u
X21 a_2128_440# a_332_68# a_1709_68# VNW.t8 pfet_03v3 ad=0.20355p pd=1.675u as=0.8418p ps=2.6u w=1.38u l=0.28u
X22 a_1315_24# a_853_68# VSS.t2 VPW.t2 nfet_03v3 ad=0.305p pd=1.61u as=0.26p ps=1.52u w=1u l=0.28u
X23 VDD.t5 a_2187_24# Q.t3 VNW.t5 pfet_03v3 ad=0.8487p pd=3.99u as=0.3588p ps=1.9u w=1.38u l=0.28u
X24 VDD.t1 CLK.t1 a_28_68# VNW.t12 pfet_03v3 ad=0.3588p pd=1.9u as=0.6072p ps=3.64u w=1.38u l=0.28u
X25 a_332_68# a_28_68# VSS.t8 VPW.t9 nfet_03v3 ad=0.485p pd=2.97u as=0.26p ps=1.52u w=1u l=0.28u
R0 VSS.n6 VSS.t7 10.9684
R1 VSS.n4 VSS.n2 6.38659
R2 VSS.n5 VSS.n1 6.38659
R3 VSS.n7 VSS.n0 6.38659
R4 VSS.n3 VSS.t5 5.2398
R5 VSS.n3 VSS.t4 4.9998
R6 VSS.n2 VSS.t0 1.6385
R7 VSS.n2 VSS.t3 1.6385
R8 VSS.n1 VSS.t2 1.6385
R9 VSS.n1 VSS.t6 1.6385
R10 VSS.n0 VSS.t8 1.6385
R11 VSS.n0 VSS.t1 1.6385
R12 VSS.n6 VSS.n5 0.677
R13 VSS.n5 VSS.n4 0.6545
R14 VSS.n4 VSS.n3 0.233
R15 VSS.n7 VSS.n6 0.22325
R16 VSS VSS.n7 0.1685
R17 Q.n2 Q.n1 6.3005
R18 Q.n2 Q.n0 5.45585
R19 Q.n1 Q.t2 1.6385
R20 Q.n1 Q.t1 1.6385
R21 Q.n0 Q.t3 1.31934
R22 Q.n0 Q.t0 1.31934
R23 Q Q.n2 0.0360814
R24 VDD.n6 VDD.t7 9.26847
R25 VDD.n7 VDD.n0 5.28659
R26 VDD.n5 VDD.n1 5.28659
R27 VDD.n4 VDD.n2 5.28659
R28 VDD.n3 VDD.t5 3.57833
R29 VDD.n3 VDD.t4 3.33833
R30 VDD.n0 VDD.t8 1.31934
R31 VDD.n0 VDD.t1 1.31934
R32 VDD.n1 VDD.t2 1.31934
R33 VDD.n1 VDD.t6 1.31934
R34 VDD.n2 VDD.t0 1.31934
R35 VDD.n2 VDD.t3 1.31934
R36 VDD.n6 VDD.n5 0.677
R37 VDD.n5 VDD.n4 0.6545
R38 VDD.n4 VDD.n3 0.233
R39 VDD.n7 VDD.n6 0.22325
R40 VDD VDD.n7 0.1685
R41 D.n0 D.t1 27.1148
R42 D.n0 D.t0 24.2469
R43 D D.n0 8.01296
R44 CLK.n0 CLK.t1 27.839
R45 CLK.n0 CLK.t0 23.4648
R46 CLK CLK.n0 8.10909
R47 VNW.t9 VNW.t7 779.071
R48 VNW.t0 VNW.t4 600.775
R49 VNW.t10 VNW.t6 596.899
R50 VNW.t11 VNW.t8 581.395
R51 VNW.t2 VNW.t11 575.582
R52 VNW.t1 VNW.t10 406.978
R53 VNW.t4 VNW.t5 310.079
R54 VNW.t3 VNW.t0 310.079
R55 VNW.t6 VNW.t2 310.079
R56 VNW.t12 VNW.t9 310.079
R57 VNW VNW.t12 259.69
R58 VNW.t7 VNW.t1 230.62
R59 VNW.t8 VNW.t3 222.869
R60 VPW.t1 VPW.t7 2998.86
R61 VPW.t0 VPW.t4 2289.77
R62 VPW.t8 VPW.t11 2260.23
R63 VPW.t9 VPW.t10 2193.75
R64 VPW.t11 VPW.t3 1684.09
R65 VPW.t10 VPW.t1 1654.55
R66 VPW.t2 VPW.t8 1314.77
R67 VPW.t4 VPW.t5 1181.82
R68 VPW.t3 VPW.t0 1181.82
R69 VPW.t6 VPW.t2 1181.82
R70 VPW.t12 VPW.t9 1181.82
R71 VPW VPW.t12 989.774
R72 VPW.t7 VPW.t6 827.274
C0 VDD VNW 0.4184f
C1 VDD Q 0.12135f
C2 VSS VNW 0.01141f
C3 VNW CLK 0.08108f
C4 Q VSS 0.1221f
C5 a_332_68# a_1259_68# 0.00617f
C6 VDD a_853_68# 0.0886f
C7 a_853_68# VSS 0.03189f
C8 a_1259_68# a_1709_68# 0
C9 a_332_68# a_2128_440# 0.00508f
C10 a_2187_24# a_2128_440# 0.00346f
C11 a_1315_24# a_1259_68# 0.00162f
C12 a_2128_440# a_1709_68# 0.00332f
C13 a_735_440# VDD 0.00188f
C14 a_28_68# D 0.16923f
C15 a_853_68# a_1259_68# 0.00239f
C16 a_28_68# a_332_68# 0.80517f
C17 a_28_68# a_2187_24# 0.01436f
C18 VDD a_1064_440# 0.01239f
C19 a_28_68# a_1709_68# 0.16622f
C20 a_28_68# a_629_68# 0.00113f
C21 a_1064_440# VSS 0
C22 a_1315_24# a_28_68# 0.04313f
C23 a_332_68# D 0.16223f
C24 a_332_68# a_2187_24# 0.17343f
C25 a_28_68# VNW 0.40411f
C26 a_28_68# Q 0.00108f
C27 a_332_68# a_2015_68# 0.00161f
C28 a_332_68# a_1709_68# 0.2078f
C29 a_2187_24# a_1709_68# 0.44509f
C30 a_332_68# a_629_68# 0.02495f
C31 a_28_68# a_853_68# 0.66932f
C32 a_1315_24# a_332_68# 0.4611f
C33 VNW D 0.07544f
C34 a_2015_68# a_1709_68# 0.02071f
C35 a_332_68# VNW 0.27024f
C36 VNW a_2187_24# 0.33165f
C37 a_1315_24# a_1709_68# 0.02396f
C38 Q a_2187_24# 0.08051f
C39 a_853_68# D 0.22443f
C40 VNW a_1709_68# 0.09488f
C41 a_853_68# a_332_68# 0.55009f
C42 a_1315_24# VNW 0.08201f
C43 a_735_440# a_28_68# 0.01142f
C44 VDD VSS 0.05703f
C45 VDD CLK 0.01655f
C46 a_853_68# a_1709_68# 0
C47 a_853_68# a_629_68# 0.00143f
C48 a_1315_24# a_853_68# 0.37583f
C49 VSS CLK 0.01737f
C50 Q VNW 0.01013f
C51 a_735_440# D 0.00377f
C52 a_28_68# a_1064_440# 0.04755f
C53 a_735_440# a_332_68# 0.0029f
C54 a_853_68# VNW 0.10526f
C55 VSS a_1259_68# 0.00587f
C56 a_1064_440# a_332_68# 0.00441f
C57 VDD a_2128_440# 0.00747f
C58 a_1315_24# a_1064_440# 0
C59 a_28_68# VDD 1.19617f
C60 a_1064_440# a_853_68# 0.0237f
C61 a_28_68# VSS 0.18588f
C62 a_28_68# CLK 0.33037f
C63 VDD D 0.01579f
C64 VSS D 0.01048f
C65 VDD a_332_68# 0.33747f
C66 VDD a_2187_24# 0.38f
C67 a_332_68# VSS 0.80621f
C68 a_332_68# CLK 0
C69 VSS a_2187_24# 0.16699f
C70 VDD a_2015_68# 0
C71 VDD a_1709_68# 0.03802f
C72 a_1315_24# VDD 0.05435f
C73 VSS a_2015_68# 0.01409f
C74 VSS a_1709_68# 0.27865f
C75 VSS a_629_68# 0.00961f
C76 a_1315_24# VSS 0.15044f
C77 a_28_68# a_2128_440# 0.00148f
C78 VSS VPW 1.03811f
C79 Q VPW 0.03434f
C80 VDD VPW 0.72688f
C81 D VPW 0.36914f
C82 CLK VPW 0.25472f
C83 VNW VPW 5.04353f
C84 a_1709_68# VPW 0.11369f
C85 a_2187_24# VPW 0.37813f
C86 a_853_68# VPW 0.11239f
C87 a_1315_24# VPW 0.09256f
C88 a_332_68# VPW 0.34588f
C89 a_28_68# VPW 0.64175f
C90 VNW.t5 VPW 0.20344f
C91 VNW.t4 VPW 0.13858f
C92 VNW.t0 VPW 0.13858f
C93 VNW.t3 VPW 0.08108f
C94 VNW.t8 VPW 0.12236f
C95 VNW.t11 VPW 0.17602f
C96 VNW.t2 VPW 0.13474f
C97 VNW.t6 VPW 0.13799f
C98 VNW.t10 VPW 0.15273f
C99 VNW.t1 VPW 0.097f
C100 VNW.t7 VPW 0.15361f
C101 VNW.t9 VPW 0.1657f
C102 VNW.t12 VPW 0.08668f
C103 CLK.t1 VPW 0.1096f
C104 CLK.t0 VPW 0.07994f
C105 CLK.n0 VPW 0.12669f
C106 D.t1 VPW 0.13259f
C107 D.t0 VPW 0.10007f
C108 D.n0 VPW 0.15405f
C109 VDD.t8 VPW 0.03273f
C110 VDD.t1 VPW 0.03273f
C111 VDD.n0 VPW 0.06565f
C112 VDD.t7 VPW 0.18115f
C113 VDD.t2 VPW 0.03273f
C114 VDD.t6 VPW 0.03273f
C115 VDD.n1 VPW 0.06565f
C116 VDD.t0 VPW 0.03273f
C117 VDD.t3 VPW 0.03273f
C118 VDD.n2 VPW 0.06565f
C119 VDD.t4 VPW 0.08393f
C120 VDD.t5 VPW 0.12721f
C121 VDD.n3 VPW 0.49245f
C122 VDD.n4 VPW 0.33965f
C123 VDD.n5 VPW 0.50167f
C124 VDD.n6 VPW 0.40632f
C125 VDD.n7 VPW 0.15876f
C126 Q.t3 VPW 0.03151f
C127 Q.t0 VPW 0.03151f
C128 Q.n0 VPW 0.06577f
C129 Q.t2 VPW 0.02283f
C130 Q.t1 VPW 0.02283f
C131 Q.n1 VPW 0.04566f
C132 Q.n2 VPW 0.10864f
C133 VSS.t8 VPW 0.0187f
C134 VSS.t1 VPW 0.0187f
C135 VSS.n0 VPW 0.03753f
C136 VSS.t7 VPW 0.05438f
C137 VSS.t2 VPW 0.0187f
C138 VSS.t6 VPW 0.0187f
C139 VSS.n1 VPW 0.03753f
C140 VSS.t0 VPW 0.0187f
C141 VSS.t3 VPW 0.0187f
C142 VSS.n2 VPW 0.03753f
C143 VSS.t4 VPW 0.04983f
C144 VSS.t5 VPW 0.07451f
C145 VSS.n3 VPW 0.34712f
C146 VSS.n4 VPW 0.26784f
C147 VSS.n5 VPW 0.39559f
C148 VSS.n6 VPW 0.28055f
C149 VSS.n7 VPW 0.1252f
.ends

* NGSPICE file created from gf180mcu_as_sc_mcu7t3v3__dfxtp_4.ext - technology: gf180mcuD

.subckt gf180mcu_as_sc_mcu7t3v3__dfxtp_4 VDD VNW VPW VSS CLK D Q
X0 a_1709_68# a_28_68# a_1315_24# VNW.t11 pfet_03v3 ad=0.8418p pd=2.6u as=0.83145p ps=2.585u w=1.38u l=0.28u
X1 a_853_68# D.t0 a_629_68# VPW.t13 nfet_03v3 ad=0.875p pd=2.75u as=0.42p ps=1.84u w=1u l=0.28u
X2 Q.t2 a_2187_24# VDD.t2 VNW.t3 pfet_03v3 ad=0.36225p pd=1.905u as=0.3588p ps=1.9u w=1.38u l=0.28u
X3 VSS.t7 a_1315_24# a_1259_68# VPW.t6 nfet_03v3 ad=0.26p pd=1.52u as=0.14p ps=1.28u w=1u l=0.28u
X4 a_1709_68# a_332_68# a_1315_24# VPW.t8 nfet_03v3 ad=0.625p pd=2.25u as=0.305p ps=1.61u w=1u l=0.28u
X5 a_2015_68# a_28_68# a_1709_68# VPW.t11 nfet_03v3 ad=0.43p pd=1.86u as=0.625p ps=2.25u w=1u l=0.28u
X6 a_332_68# a_28_68# VDD.t9 VNW.t9 pfet_03v3 ad=0.6693p pd=3.73u as=0.3588p ps=1.9u w=1.38u l=0.28u
X7 VSS.t6 CLK.t0 a_28_68# VPW.t14 nfet_03v3 ad=0.26p pd=1.52u as=0.44p ps=2.88u w=1u l=0.28u
X8 a_1259_68# a_332_68# a_853_68# VPW.t7 nfet_03v3 ad=0.14p pd=1.28u as=0.875p ps=2.75u w=1u l=0.28u
X9 VDD.t4 a_2187_24# a_2128_440# VNW.t0 pfet_03v3 ad=0.3588p pd=1.9u as=0.20355p ps=1.675u w=1.38u l=0.28u
X10 a_2187_24# a_1709_68# VSS.t5 VPW.t5 nfet_03v3 ad=0.55p pd=3.1u as=0.26p ps=1.52u w=1u l=0.28u
X11 Q.t6 a_2187_24# VSS.t2 VPW.t3 nfet_03v3 ad=0.2625p pd=1.525u as=0.26p ps=1.52u w=1u l=0.28u
X12 VSS.t3 a_2187_24# Q.t7 VPW.t4 nfet_03v3 ad=0.58p pd=3.16u as=0.2625p ps=1.525u w=1u l=0.28u
X13 VDD.t7 a_1315_24# a_1064_440# VNW.t6 pfet_03v3 ad=0.3588p pd=1.9u as=0.86595p ps=2.635u w=1.38u l=0.28u
X14 a_735_440# a_332_68# VDD.t8 VNW.t7 pfet_03v3 ad=0.2139p pd=1.69u as=1.3317p ps=4.69u w=1.38u l=0.285u
X15 a_853_68# D.t1 a_735_440# VNW.t13 pfet_03v3 ad=0.5313p pd=2.15u as=0.2139p ps=1.69u w=1.38u l=0.28u
X16 a_629_68# a_28_68# VSS.t9 VPW.t10 nfet_03v3 ad=0.42p pd=1.84u as=0.44p ps=2.88u w=1u l=0.28u
X17 VSS.t1 a_2187_24# Q.t5 VPW.t2 nfet_03v3 ad=0.26p pd=1.52u as=0.26p ps=1.52u w=1u l=0.28u
X18 VDD.t3 a_2187_24# Q.t1 VNW.t4 pfet_03v3 ad=0.8004p pd=3.92u as=0.36225p ps=1.905u w=1.38u l=0.28u
X19 VSS.t0 a_2187_24# a_2015_68# VPW.t0 nfet_03v3 ad=0.26p pd=1.52u as=0.43p ps=1.86u w=1u l=0.28u
X20 a_1315_24# a_853_68# VDD.t10 VNW.t12 pfet_03v3 ad=0.83145p pd=2.585u as=0.3588p ps=1.9u w=1.38u l=0.28u
X21 Q.t0 a_2187_24# VDD.t0 VNW.t1 pfet_03v3 ad=0.3588p pd=1.9u as=0.6072p ps=3.64u w=1.38u l=0.28u
X22 a_2187_24# a_1709_68# VDD.t5 VNW.t5 pfet_03v3 ad=0.759p pd=3.86u as=0.3588p ps=1.9u w=1.38u l=0.28u
X23 Q.t4 a_2187_24# VSS.t4 VPW.t1 nfet_03v3 ad=0.26p pd=1.52u as=0.44p ps=2.88u w=1u l=0.28u
X24 a_1064_440# a_28_68# a_853_68# VNW.t10 pfet_03v3 ad=0.86595p pd=2.635u as=0.5313p ps=2.15u w=1.38u l=0.285u
X25 a_2128_440# a_332_68# a_1709_68# VNW.t8 pfet_03v3 ad=0.20355p pd=1.675u as=0.8418p ps=2.6u w=1.38u l=0.28u
X26 a_1315_24# a_853_68# VSS.t10 VPW.t12 nfet_03v3 ad=0.305p pd=1.61u as=0.26p ps=1.52u w=1u l=0.28u
X27 VDD.t1 a_2187_24# Q.t3 VNW.t2 pfet_03v3 ad=0.3588p pd=1.9u as=0.3588p ps=1.9u w=1.38u l=0.28u
X28 VDD.t6 CLK.t1 a_28_68# VNW.t14 pfet_03v3 ad=0.3588p pd=1.9u as=0.6072p ps=3.64u w=1.38u l=0.28u
X29 a_332_68# a_28_68# VSS.t8 VPW.t9 nfet_03v3 ad=0.485p pd=2.97u as=0.26p ps=1.52u w=1u l=0.28u
R0 VSS.n8 VSS.t9 10.9684
R1 VSS.n6 VSS.n2 6.38659
R2 VSS.n7 VSS.n1 6.38659
R3 VSS.n9 VSS.n0 6.38659
R4 VSS.n4 VSS.t3 5.24055
R5 VSS.n5 VSS.t4 4.9998
R6 VSS.n4 VSS.n3 3.3618
R7 VSS.n3 VSS.t2 1.6385
R8 VSS.n3 VSS.t1 1.6385
R9 VSS.n2 VSS.t5 1.6385
R10 VSS.n2 VSS.t0 1.6385
R11 VSS.n1 VSS.t10 1.6385
R12 VSS.n1 VSS.t7 1.6385
R13 VSS.n0 VSS.t8 1.6385
R14 VSS.n0 VSS.t6 1.6385
R15 VSS.n8 VSS.n7 0.677
R16 VSS.n7 VSS.n6 0.6545
R17 VSS.n5 VSS.n4 0.2405
R18 VSS.n6 VSS.n5 0.233
R19 VSS.n9 VSS.n8 0.22325
R20 VSS VSS.n9 0.1685
R21 Q.n3 Q.n2 6.3005
R22 Q.n6 Q.n5 6.3005
R23 Q Q.n1 5.32922
R24 Q.n4 Q.n0 5.32922
R25 Q.n5 Q.t7 1.67
R26 Q.n2 Q.t5 1.6385
R27 Q.n2 Q.t4 1.6385
R28 Q.n5 Q.t6 1.6385
R29 Q.n0 Q.t1 1.3447
R30 Q.n1 Q.t3 1.31934
R31 Q.n1 Q.t0 1.31934
R32 Q.n0 Q.t2 1.31934
R33 Q.n4 Q 0.355924
R34 Q Q.n3 0.127128
R35 Q.n6 Q.n4 0.127128
R36 Q.n3 Q 0.0360814
R37 Q Q.n6 0.0360814
R38 VDD.n8 VDD.t8 9.26847
R39 VDD.n9 VDD.n0 5.28659
R40 VDD.n7 VDD.n1 5.28659
R41 VDD.n6 VDD.n2 5.28659
R42 VDD.n4 VDD.t3 3.57908
R43 VDD.n5 VDD.t0 3.33833
R44 VDD.n4 VDD.n3 2.01949
R45 VDD.n0 VDD.t9 1.31934
R46 VDD.n0 VDD.t6 1.31934
R47 VDD.n1 VDD.t10 1.31934
R48 VDD.n1 VDD.t7 1.31934
R49 VDD.n2 VDD.t5 1.31934
R50 VDD.n2 VDD.t4 1.31934
R51 VDD.n3 VDD.t2 1.31934
R52 VDD.n3 VDD.t1 1.31934
R53 VDD.n8 VDD.n7 0.677
R54 VDD.n7 VDD.n6 0.6545
R55 VDD.n5 VDD.n4 0.2405
R56 VDD.n6 VDD.n5 0.233
R57 VDD.n9 VDD.n8 0.22325
R58 VDD VDD.n9 0.1685
R59 D.n0 D.t1 27.1148
R60 D.n0 D.t0 24.2469
R61 D D.n0 8.01296
R62 CLK.n0 CLK.t1 27.839
R63 CLK.n0 CLK.t0 23.4648
R64 CLK CLK.n0 8.10909
R65 VNW.t9 VNW.t7 779.071
R66 VNW.t5 VNW.t1 600.775
R67 VNW.t10 VNW.t6 596.899
R68 VNW.t11 VNW.t8 581.395
R69 VNW.t12 VNW.t11 575.582
R70 VNW.t13 VNW.t10 406.978
R71 VNW.t3 VNW.t4 312.017
R72 VNW.t2 VNW.t3 310.079
R73 VNW.t1 VNW.t2 310.079
R74 VNW.t0 VNW.t5 310.079
R75 VNW.t6 VNW.t12 310.079
R76 VNW.t14 VNW.t9 310.079
R77 VNW VNW.t14 259.69
R78 VNW.t7 VNW.t13 230.62
R79 VNW.t8 VNW.t0 222.869
R80 VPW.t13 VPW.t7 2998.86
R81 VPW.t5 VPW.t1 2289.77
R82 VPW.t8 VPW.t11 2260.23
R83 VPW.t9 VPW.t10 2193.75
R84 VPW.t11 VPW.t0 1684.09
R85 VPW.t10 VPW.t13 1654.55
R86 VPW.t12 VPW.t8 1314.77
R87 VPW.t3 VPW.t4 1189.2
R88 VPW.t2 VPW.t3 1181.82
R89 VPW.t1 VPW.t2 1181.82
R90 VPW.t0 VPW.t5 1181.82
R91 VPW.t6 VPW.t12 1181.82
R92 VPW.t14 VPW.t9 1181.82
R93 VPW VPW.t14 989.774
R94 VPW.t7 VPW.t6 827.274
C0 a_332_68# VDD 0.33747f
C1 VDD a_1315_24# 0.05435f
C2 a_28_68# a_853_68# 0.66932f
C3 D a_735_440# 0.00377f
C4 a_853_68# VNW 0.10526f
C5 a_1709_68# a_332_68# 0.2078f
C6 D a_28_68# 0.16923f
C7 D VNW 0.07544f
C8 a_1709_68# a_1315_24# 0.02396f
C9 a_853_68# a_1064_440# 0.0237f
C10 a_332_68# a_853_68# 0.55009f
C11 a_853_68# a_1315_24# 0.37583f
C12 D a_332_68# 0.16223f
C13 a_28_68# CLK 0.33037f
C14 a_2128_440# a_2187_24# 0.00346f
C15 VSS Q 0.32704f
C16 CLK VNW 0.08108f
C17 VDD a_2128_440# 0.00747f
C18 a_629_68# a_853_68# 0.00143f
C19 a_332_68# a_1259_68# 0.00617f
C20 a_28_68# VSS 0.18588f
C21 VSS VNW 0.01237f
C22 a_1259_68# a_1315_24# 0.00162f
C23 a_2015_68# VDD 0
C24 VDD a_2187_24# 0.44569f
C25 a_332_68# CLK 0
C26 a_1709_68# a_2128_440# 0.00332f
C27 VSS a_1064_440# 0
C28 a_332_68# VSS 0.80621f
C29 a_2015_68# a_1709_68# 0.02071f
C30 a_1709_68# a_2187_24# 0.44509f
C31 VSS a_1315_24# 0.15044f
C32 a_1709_68# VDD 0.03802f
C33 a_629_68# VSS 0.00961f
C34 VDD a_853_68# 0.0886f
C35 D VDD 0.01579f
C36 a_28_68# Q 0.00201f
C37 Q VNW 0.01808f
C38 a_1709_68# a_853_68# 0
C39 a_28_68# a_735_440# 0.01142f
C40 a_28_68# VNW 0.40393f
C41 VDD CLK 0.01655f
C42 a_1709_68# a_1259_68# 0
C43 a_2015_68# VSS 0.01409f
C44 a_2187_24# VSS 0.22109f
C45 a_332_68# a_735_440# 0.0029f
C46 VDD VSS 0.05768f
C47 D a_853_68# 0.22443f
C48 a_28_68# a_1064_440# 0.04755f
C49 a_332_68# a_28_68# 0.80517f
C50 a_332_68# VNW 0.27024f
C51 a_1259_68# a_853_68# 0.00239f
C52 a_28_68# a_1315_24# 0.04313f
C53 VNW a_1315_24# 0.08201f
C54 a_1709_68# VSS 0.27865f
C55 a_332_68# a_1064_440# 0.00441f
C56 a_629_68# a_28_68# 0.00113f
C57 a_1064_440# a_1315_24# 0
C58 VSS a_853_68# 0.03189f
C59 a_332_68# a_1315_24# 0.4611f
C60 D VSS 0.01048f
C61 a_629_68# a_332_68# 0.02495f
C62 a_2128_440# a_28_68# 0.00148f
C63 VSS a_1259_68# 0.00587f
C64 a_2187_24# Q 0.17713f
C65 VDD Q 0.32176f
C66 VSS CLK 0.01737f
C67 VDD a_735_440# 0.00188f
C68 a_2187_24# a_28_68# 0.0152f
C69 a_2187_24# VNW 0.508f
C70 VDD a_28_68# 1.19648f
C71 a_332_68# a_2128_440# 0.00508f
C72 VDD VNW 0.49192f
C73 VDD a_1064_440# 0.01239f
C74 a_2015_68# a_332_68# 0.00161f
C75 a_1709_68# a_28_68# 0.16622f
C76 a_332_68# a_2187_24# 0.17343f
C77 a_1709_68# VNW 0.09488f
C78 VSS VPW 1.13744f
C79 Q VPW 0.18128f
C80 VDD VPW 0.78874f
C81 D VPW 0.36914f
C82 CLK VPW 0.25472f
C83 VNW VPW 5.56645f
C84 a_1709_68# VPW 0.11369f
C85 a_2187_24# VPW 0.59094f
C86 a_853_68# VPW 0.11239f
C87 a_1315_24# VPW 0.09256f
C88 a_332_68# VPW 0.34588f
C89 a_28_68# VPW 0.63905f
C90 VNW.t4 VPW 0.21875f
C91 VNW.t3 VPW 0.09739f
C92 VNW.t2 VPW 0.09709f
C93 VNW.t1 VPW 0.1426f
C94 VNW.t5 VPW 0.1426f
C95 VNW.t0 VPW 0.08343f
C96 VNW.t8 VPW 0.12591f
C97 VNW.t11 VPW 0.18113f
C98 VNW.t12 VPW 0.13865f
C99 VNW.t6 VPW 0.14199f
C100 VNW.t10 VPW 0.15716f
C101 VNW.t13 VPW 0.09982f
C102 VNW.t7 VPW 0.15807f
C103 VNW.t9 VPW 0.17051f
C104 VNW.t14 VPW 0.0892f
C105 CLK.t1 VPW 0.1096f
C106 CLK.t0 VPW 0.07994f
C107 CLK.n0 VPW 0.12669f
C108 D.t1 VPW 0.13259f
C109 D.t0 VPW 0.10007f
C110 D.n0 VPW 0.15405f
C111 VDD.t9 VPW 0.03244f
C112 VDD.t6 VPW 0.03244f
C113 VDD.n0 VPW 0.06508f
C114 VDD.t8 VPW 0.17955f
C115 VDD.t10 VPW 0.03244f
C116 VDD.t7 VPW 0.03244f
C117 VDD.n1 VPW 0.06508f
C118 VDD.t5 VPW 0.03244f
C119 VDD.t4 VPW 0.03244f
C120 VDD.n2 VPW 0.06508f
C121 VDD.t0 VPW 0.08319f
C122 VDD.t2 VPW 0.03244f
C123 VDD.t1 VPW 0.03244f
C124 VDD.n3 VPW 0.07142f
C125 VDD.t3 VPW 0.12119f
C126 VDD.n4 VPW 0.46254f
C127 VDD.n5 VPW 0.25887f
C128 VDD.n6 VPW 0.33667f
C129 VDD.n7 VPW 0.49726f
C130 VDD.n8 VPW 0.40275f
C131 VDD.n9 VPW 0.15736f
C132 Q.t1 VPW 0.03708f
C133 Q.t2 VPW 0.03638f
C134 Q.n0 VPW 0.07446f
C135 Q.t3 VPW 0.03638f
C136 Q.t0 VPW 0.03638f
C137 Q.n1 VPW 0.07376f
C138 Q.t5 VPW 0.02636f
C139 Q.t4 VPW 0.02636f
C140 Q.n2 VPW 0.05272f
C141 Q.n3 VPW 0.03379f
C142 Q.n4 VPW 0.12865f
C143 Q.t7 VPW 0.02687f
C144 Q.t6 VPW 0.02636f
C145 Q.n5 VPW 0.05323f
C146 Q.n6 VPW 0.03379f
C147 VSS.t8 VPW 0.01879f
C148 VSS.t6 VPW 0.01879f
C149 VSS.n0 VPW 0.0377f
C150 VSS.t9 VPW 0.05464f
C151 VSS.t10 VPW 0.01879f
C152 VSS.t7 VPW 0.01879f
C153 VSS.n1 VPW 0.0377f
C154 VSS.t5 VPW 0.01879f
C155 VSS.t0 VPW 0.01879f
C156 VSS.n2 VPW 0.0377f
C157 VSS.t4 VPW 0.05007f
C158 VSS.t2 VPW 0.01879f
C159 VSS.t1 VPW 0.01879f
C160 VSS.n3 VPW 0.03928f
C161 VSS.t3 VPW 0.07172f
C162 VSS.n4 VPW 0.34055f
C163 VSS.n5 VPW 0.18635f
C164 VSS.n6 VPW 0.2691f
C165 VSS.n7 VPW 0.39745f
C166 VSS.n8 VPW 0.28187f
C167 VSS.n9 VPW 0.12579f
.ends

* NGSPICE file created from gf180mcu_as_sc_mcu7t3v3__diode_2.ext - technology: gf180mcuD

.subckt gf180mcu_as_sc_mcu7t3v3__diode_2 VDD VNW VPW VSS DIODE
D0 DIODE.t1 VNW.t0 diode_pd2nw_03v3 pj=1.93u area=0.2295p
D1 VPW.t0 DIODE.t0 diode_nd2ps_03v3 pj=1.83u area=0.209p
R0 DIODE.n0 DIODE.t0 6.3005
R1 DIODE.n0 DIODE.t1 5.676
R2 DIODE DIODE.n0 0.053
R3 VNW VNW.t0 525.254
R4 VPW VPW.t0 1920.45
C0 VNW DIODE 0.03015f
C1 DIODE VDD 0.01657f
C2 VNW VSS 0.00757f
C3 VDD VSS 0.01016f
C4 DIODE VSS 0.02863f
C5 VNW VDD 0.04853f
C6 VSS VPW 0.17299f
C7 VDD VPW 0.16245f
C8 DIODE VPW 0.13912f
C9 VNW VPW 0.65313f
C10 VNW.t0 VPW 0.04614f
C11 DIODE.t1 VPW 0.01873f
C12 DIODE.t0 VPW 0.01541f
C13 DIODE.n0 VPW 0.03928f
.ends

* NGSPICE file created from gf180mcu_as_sc_mcu7t3v3__fill_1.ext - technology: gf180mcuD

.subckt gf180mcu_as_sc_mcu7t3v3__fill_1 VDD VNW VPW VSS
C0 VDD VSS 0.00694f
C1 VNW VDD 0.02996f
C2 VNW VSS 0.00541f
C3 VSS VPW 0.10159f
C4 VDD VPW 0.10159f
C5 VNW VPW 0.475f
.ends

* NGSPICE file created from gf180mcu_as_sc_mcu7t3v3__fill_2.ext - technology: gf180mcuD

.subckt gf180mcu_as_sc_mcu7t3v3__fill_2 VDD VNW VPW VSS
C0 VDD VSS 0.01388f
C1 VNW VDD 0.05248f
C2 VNW VSS 0.01082f
C3 VSS VPW 0.15586f
C4 VDD VPW 0.15586f
C5 VNW VPW 0.67631f
.ends

* NGSPICE file created from gf180mcu_as_sc_mcu7t3v3__fill_4.ext - technology: gf180mcuD

.subckt gf180mcu_as_sc_mcu7t3v3__fill_4 VDD VNW VPW VSS
C0 VNW VSS 0.02164f
C1 VDD VSS 0.02775f
C2 VNW VDD 0.09753f
C3 VSS VPW 0.26441f
C4 VDD VPW 0.26441f
C5 VNW VPW 1.07893f
.ends

* NGSPICE file created from gf180mcu_as_sc_mcu7t3v3__fill_8.ext - technology: gf180mcuD

.subckt gf180mcu_as_sc_mcu7t3v3__fill_8 VDD VNW VPW VSS
C0 VNW VDD 0.18762f
C1 VNW VSS 0.04329f
C2 VDD VSS 0.0555f
C3 VSS VPW 0.4815f
C4 VDD VPW 0.4815f
C5 VNW VPW 1.88417f
.ends

* NGSPICE file created from gf180mcu_as_sc_mcu7t3v3__fillcap_16.ext - technology: gf180mcuD

.subckt gf180mcu_as_sc_mcu7t3v3__fillcap_16 VDD VNW VPW VSS
X0 a_126_406# a_28_498# VSS.t0 VPW.t0 nfet_03v3 ad=0.4356p pd=2.86u as=0.4851p ps=2.96u w=0.99u l=7.75u
X1 VDD.t0 a_126_406# a_28_498# VNW.t0 pfet_03v3 ad=0.4796p pd=3.06u as=0.5341p ps=3.16u w=1.09u l=7.75u
R0 VSS VSS.t0 8.38295
R1 VDD VDD.t0 5.79905
R2 VNW VNW.t0 1726.74
R3 VPW VPW.t0 6581.25
C0 VSS a_28_498# 0.39207f
C1 VDD VNW 0.20142f
C2 VSS VNW 0.01768f
C3 a_28_498# VNW 0.19991f
C4 VDD a_126_406# 0.45682f
C5 VSS a_126_406# 0.07931f
C6 a_126_406# a_28_498# 0.55902f
C7 VDD VSS 0.09276f
C8 a_126_406# VNW 1.00233f
C9 VDD a_28_498# 0.11174f
C10 VSS VPW 1.08628f
C11 VDD VPW 1.12849f
C12 VNW VPW 3.43215f
C13 a_28_498# VPW 1.09998f
C14 a_126_406# VPW 0.24716f
C15 VNW.t0 VPW 1.02945f
C16 VDD.t0 VPW 0.15081f
C17 VSS.t0 VPW 0.04f
.ends

* NGSPICE file created from gf180mcu_as_sc_mcu7t3v3__fillcap_4.ext - technology: gf180mcuD

.subckt gf180mcu_as_sc_mcu7t3v3__fillcap_4 VDD VNW VPW VSS
X0 a_126_408# a_28_500# VSS.t0 VPW.t0 nfet_03v3 ad=0.44p pd=2.88u as=0.49p ps=2.98u w=1u l=1.03u
X1 VDD.t0 a_126_408# a_28_500# VNW.t0 pfet_03v3 ad=0.4752p pd=3.04u as=0.5292p ps=3.14u w=1.08u l=1.03u
R0 VSS VSS.t0 8.3813
R1 VDD VDD.t0 4.79086
R2 VNW VNW.t0 424.42
R3 VPW VPW.t0 1617.61
C0 a_126_408# VNW 0.1953f
C1 VDD a_28_500# 0.10086f
C2 VSS a_28_500# 0.09315f
C3 VDD VNW 0.08181f
C4 VSS VNW 0.00512f
C5 a_28_500# VNW 0.06857f
C6 VDD a_126_408# 0.14077f
C7 VSS a_126_408# 0.08f
C8 a_126_408# a_28_500# 0.1744f
C9 VDD VSS 0.00957f
C10 VSS VPW 0.34669f
C11 VDD VPW 0.4264f
C12 VNW VPW 1.07603f
C13 a_28_500# VPW 0.2632f
C14 a_126_408# VPW 0.12562f
C15 VNW.t0 VPW 0.23452f
C16 VDD.t0 VPW 0.06885f
C17 VSS.t0 VPW 0.04029f
.ends

* NGSPICE file created from gf180mcu_as_sc_mcu7t3v3__fillcap_8.ext - technology: gf180mcuD

.subckt gf180mcu_as_sc_mcu7t3v3__fillcap_8 VDD VNW VPW VSS
X0 a_126_406# a_28_498# VSS.t0 VPW.t0 nfet_03v3 ad=0.4356p pd=2.86u as=0.4851p ps=2.96u w=0.99u l=3.27u
X1 VDD.t0 a_126_406# a_28_498# VNW.t0 pfet_03v3 ad=0.4796p pd=3.06u as=0.5341p ps=3.16u w=1.09u l=3.27u
R0 VSS VSS.t0 8.38898
R1 VDD VDD.t0 5.1114
R2 VNW VNW.t0 858.528
R3 VPW VPW.t0 3272.16
C0 a_28_498# VNW 0.11383f
C1 VDD a_126_406# 0.25385f
C2 VSS a_126_406# 0.05033f
C3 a_126_406# a_28_498# 0.29597f
C4 VDD VSS 0.03701f
C5 a_126_406# VNW 0.462f
C6 VDD a_28_498# 0.09499f
C7 VSS a_28_498# 0.19552f
C8 VDD VNW 0.12692f
C9 VSS VNW 0.0093f
C10 VSS VPW 0.57053f
C11 VDD VPW 0.66985f
C12 VNW VPW 1.86494f
C13 a_28_498# VPW 0.54027f
C14 a_126_406# VPW 0.14856f
C15 VNW.t0 VPW 0.50037f
C16 VDD.t0 VPW 0.08755f
C17 VSS.t0 VPW 0.03659f
.ends

* NGSPICE file created from gf180mcu_as_sc_mcu7t3v3__inv_2.ext - technology: gf180mcuD

.subckt gf180mcu_as_sc_mcu7t3v3__inv_2 VDD VNW VPW VSS Y A
X0 VDD.t0 A.t2 Y.t1 VNW.t1 pfet_03v3 ad=0.6072p pd=3.64u as=0.3588p ps=1.9u w=1.38u l=0.28u
X1 Y.t0 A.t1 VSS.t0 VPW.t0 nfet_03v3 ad=0.26p pd=1.52u as=0.44p ps=2.88u w=1u l=0.28u
X2 Y.t3 A.t3 VDD.t1 VNW.t0 pfet_03v3 ad=0.3588p pd=1.9u as=0.6072p ps=3.64u w=1.38u l=0.28u
X3 VSS.t1 A.t0 Y.t2 VPW.t1 nfet_03v3 ad=0.44p pd=2.88u as=0.26p ps=1.52u w=1u l=0.28u
R0 VSS.n0 VSS.t1 5.22024
R1 VSS.n0 VSS.t0 4.9685
R2 VSS VSS.n0 0.0485
R3 Y Y.n0 6.42963
R4 Y Y.n1 3.07137
R5 Y.n0 Y.t2 1.6385
R6 Y.n0 Y.t0 1.6385
R7 Y.n1 Y.t1 1.31934
R8 Y.n1 Y.t3 1.31934
R9 VDD.n0 VDD.t0 4.42934
R10 VDD.n0 VDD.t1 4.1776
R11 VDD VDD.n0 0.0485
R12 A.n2 A.t3 27.0187
R13 A.n0 A.t2 24.8987
R14 A.n1 A.t1 23.4442
R15 A.n0 A.t0 20.4666
R16 A.n1 A.n0 15.5424
R17 A A.n2 8.07704
R18 A.n2 A.n1 0.480763
R19 VNW.t0 VNW.t1 310.079
R20 VNW VNW.t0 259.69
R21 VPW.t0 VPW.t1 1181.82
R22 VPW VPW.t0 989.774
C0 VNW VSS 0.00519f
C1 VDD VNW 0.10249f
C2 VDD VSS 0.02646f
C3 VNW A 0.1785f
C4 A VSS 0.09371f
C5 VNW Y 0.0287f
C6 Y VSS 0.18339f
C7 VDD A 0.11992f
C8 VDD Y 0.24006f
C9 A Y 0.17974f
C10 VSS VPW 0.26638f
C11 Y VPW 0.27606f
C12 VDD VPW 0.22195f
C13 A VPW 0.34272f
C14 VNW VPW 1.04254f
C15 VNW.t1 VPW 0.15744f
C16 VNW.t0 VPW 0.07466f
C17 A.t3 VPW 0.077f
C18 A.t2 VPW 0.07327f
C19 A.t0 VPW 0.05201f
C20 A.n0 VPW 0.10752f
C21 A.t1 VPW 0.05689f
C22 A.n1 VPW 0.0713f
C23 A.n2 VPW 0.05015f
C24 VDD.t1 VPW 0.07525f
C25 VDD.t0 VPW 0.08471f
C26 VDD.n0 VPW 0.31409f
C27 Y.t2 VPW 0.0409f
C28 Y.t0 VPW 0.0409f
C29 Y.n0 VPW 0.08261f
C30 Y.t1 VPW 0.05644f
C31 Y.t3 VPW 0.05644f
C32 Y.n1 VPW 0.12863f
C33 VSS.t0 VPW 0.03998f
C34 VSS.t1 VPW 0.04529f
C35 VSS.n0 VPW 0.21232f
.ends

* NGSPICE file created from gf180mcu_as_sc_mcu7t3v3__inv_4.ext - technology: gf180mcuD

.subckt gf180mcu_as_sc_mcu7t3v3__inv_4 VDD VNW VPW VSS Y A
X0 VDD.t2 A.t6 Y.t3 VNW.t1 pfet_03v3 ad=0.3588p pd=1.9u as=0.3588p ps=1.9u w=1.38u l=0.28u
X1 Y.t4 A.t3 VSS.t1 VPW.t0 nfet_03v3 ad=0.26p pd=1.52u as=0.44p ps=2.88u w=1u l=0.28u
X2 Y.t1 A.t5 VDD.t0 VNW.t2 pfet_03v3 ad=0.3588p pd=1.9u as=0.3588p ps=1.9u w=1.38u l=0.28u
X3 VSS.t2 A.t0 Y.t5 VPW.t3 nfet_03v3 ad=0.52p pd=3.04u as=0.26p ps=1.52u w=1u l=0.28u
X4 VDD.t3 A.t4 Y.t7 VNW.t3 pfet_03v3 ad=0.7176p pd=3.8u as=0.3588p ps=1.9u w=1.38u l=0.28u
X5 Y.t6 A.t1 VSS.t3 VPW.t2 nfet_03v3 ad=0.26p pd=1.52u as=0.26p ps=1.52u w=1u l=0.28u
X6 Y.t2 A.t7 VDD.t1 VNW.t0 pfet_03v3 ad=0.3588p pd=1.9u as=0.6072p ps=3.64u w=1.38u l=0.28u
X7 VSS.t0 A.t2 Y.t0 VPW.t1 nfet_03v3 ad=0.26p pd=1.52u as=0.26p ps=1.52u w=1u l=0.28u
R0 VSS.n1 VSS.t2 5.2398
R1 VSS.n2 VSS.t1 4.9685
R2 VSS.n1 VSS.n0 3.34224
R3 VSS.n0 VSS.t3 1.6385
R4 VSS.n0 VSS.t0 1.6385
R5 VSS.n2 VSS.n1 0.2405
R6 VSS VSS.n2 0.0485
R7 Y.n3 Y.n2 6.51376
R8 Y Y.n0 6.33963
R9 Y.n3 Y.n1 2.93702
R10 Y.n5 Y.n4 2.92528
R11 Y.n0 Y.t0 1.6385
R12 Y.n0 Y.t4 1.6385
R13 Y.n2 Y.t5 1.6385
R14 Y.n2 Y.t6 1.6385
R15 Y.n1 Y.t7 1.31934
R16 Y.n1 Y.t1 1.31934
R17 Y.n4 Y.t3 1.31934
R18 Y.n4 Y.t2 1.31934
R19 Y.n5 Y.n3 0.536587
R20 Y Y.n5 0.146587
R21 VDD.n2 VDD.t1 4.1776
R22 VDD.n1 VDD.t3 3.57833
R23 VDD.n1 VDD.n0 2.8705
R24 VDD.n0 VDD.t0 1.31934
R25 VDD.n0 VDD.t2 1.31934
R26 VDD.n2 VDD.n1 0.2405
R27 VDD VDD.n2 0.0485
R28 A.n3 A.t6 27.5059
R29 A.n6 A.t7 27.0187
R30 A.n2 A.t1 25.9416
R31 A.n0 A.t0 24.7684
R32 A.n1 A.t5 24.638
R33 A.n4 A.t2 24.5076
R34 A.n5 A.t3 23.4442
R35 A.n0 A.t4 20.5969
R36 A.n1 A.n0 15.5424
R37 A.n3 A.n2 12.2457
R38 A.n5 A.n4 12.2457
R39 A A.n6 8.07704
R40 A.n2 A.n1 2.86836
R41 A.n4 A.n3 1.43443
R42 A.n6 A.n5 0.480763
R43 VNW.t2 VNW.t3 310.079
R44 VNW.t1 VNW.t2 310.079
R45 VNW.t0 VNW.t1 310.079
R46 VNW VNW.t0 259.69
R47 VPW.t2 VPW.t3 1181.82
R48 VPW.t1 VPW.t2 1181.82
R49 VPW.t0 VPW.t1 1181.82
R50 VPW VPW.t0 989.774
C0 VSS A 0.15051f
C1 Y VNW 0.05217f
C2 VDD A 0.17757f
C3 VSS VNW 0.00555f
C4 VDD VNW 0.16005f
C5 Y VSS 0.22184f
C6 VDD Y 0.55112f
C7 VDD VSS 0.03275f
C8 VNW A 0.35536f
C9 Y A 0.27732f
C10 VSS VPW 0.36738f
C11 Y VPW 0.09887f
C12 VDD VPW 0.28937f
C13 A VPW 0.5436f
C14 VNW VPW 1.57761f
C15 VNW.t3 VPW 0.19544f
C16 VNW.t2 VPW 0.09592f
C17 VNW.t1 VPW 0.09592f
C18 VNW.t0 VPW 0.08813f
C19 A.t7 VPW 0.06762f
C20 A.t4 VPW 0.05875f
C21 A.t0 VPW 0.05128f
C22 A.n0 VPW 0.09443f
C23 A.t5 VPW 0.06401f
C24 A.n1 VPW 0.06064f
C25 A.t1 VPW 0.0528f
C26 A.n2 VPW 0.05707f
C27 A.t6 VPW 0.06774f
C28 A.n3 VPW 0.05724f
C29 A.t2 VPW 0.05094f
C30 A.n4 VPW 0.05334f
C31 A.t3 VPW 0.04997f
C32 A.n5 VPW 0.05735f
C33 A.n6 VPW 0.04404f
C34 VDD.t1 VPW 0.08404f
C35 VDD.t0 VPW 0.03106f
C36 VDD.t2 VPW 0.03106f
C37 VDD.n0 VPW 0.06579f
C38 VDD.t3 VPW 0.10555f
C39 VDD.n1 VPW 0.41619f
C40 VDD.n2 VPW 0.17118f
C41 Y.t0 VPW 0.03601f
C42 Y.t4 VPW 0.03601f
C43 Y.n0 VPW 0.07211f
C44 Y.t7 VPW 0.04969f
C45 Y.t1 VPW 0.04969f
C46 Y.n1 VPW 0.10684f
C47 Y.t5 VPW 0.03601f
C48 Y.t6 VPW 0.03601f
C49 Y.n2 VPW 0.07294f
C50 Y.n3 VPW 0.18053f
C51 Y.t3 VPW 0.04969f
C52 Y.t2 VPW 0.04969f
C53 Y.n4 VPW 0.10695f
C54 Y.n5 VPW 0.1764f
C55 VSS.t1 VPW 0.03126f
C56 VSS.t3 VPW 0.01183f
C57 VSS.t0 VPW 0.01183f
C58 VSS.n0 VPW 0.02448f
C59 VSS.t2 VPW 0.04096f
C60 VSS.n1 VPW 0.20082f
C61 VSS.n2 VPW 0.08073f
.ends

* NGSPICE file created from gf180mcu_as_sc_mcu7t3v3__inv_6.ext - technology: gf180mcuD

.subckt gf180mcu_as_sc_mcu7t3v3__inv_6 VDD VNW VPW VSS Y A
X0 VSS.t0 A.t0 Y.t0 VPW.t5 nfet_03v3 ad=0.6p pd=3.2u as=0.26p ps=1.52u w=1u l=0.28u
X1 VDD.t3 A.t10 Y.t8 VNW.t1 pfet_03v3 ad=0.3588p pd=1.9u as=0.3588p ps=1.9u w=1.38u l=0.28u
X2 Y.t4 A.t7 VDD.t0 VNW.t4 pfet_03v3 ad=0.3588p pd=1.9u as=0.3588p ps=1.9u w=1.38u l=0.28u
X3 Y.t11 A.t5 VSS.t5 VPW.t0 nfet_03v3 ad=0.26p pd=1.52u as=0.44p ps=2.88u w=1u l=0.28u
X4 Y.t6 A.t1 VSS.t4 VPW.t4 nfet_03v3 ad=0.26p pd=1.52u as=0.26p ps=1.52u w=1u l=0.28u
X5 Y.t7 A.t9 VDD.t2 VNW.t2 pfet_03v3 ad=0.3588p pd=1.9u as=0.3588p ps=1.9u w=1.38u l=0.28u
X6 VDD.t1 A.t6 Y.t5 VNW.t5 pfet_03v3 ad=0.828p pd=3.96u as=0.3588p ps=1.9u w=1.38u l=0.28u
X7 VSS.t1 A.t2 Y.t1 VPW.t3 nfet_03v3 ad=0.26p pd=1.52u as=0.26p ps=1.52u w=1u l=0.28u
X8 VDD.t5 A.t8 Y.t10 VNW.t3 pfet_03v3 ad=0.3588p pd=1.9u as=0.3588p ps=1.9u w=1.38u l=0.28u
X9 Y.t2 A.t3 VSS.t2 VPW.t2 nfet_03v3 ad=0.26p pd=1.52u as=0.26p ps=1.52u w=1u l=0.28u
X10 Y.t9 A.t11 VDD.t4 VNW.t0 pfet_03v3 ad=0.3588p pd=1.9u as=0.6072p ps=3.64u w=1.38u l=0.28u
X11 VSS.t3 A.t4 Y.t3 VPW.t1 nfet_03v3 ad=0.26p pd=1.52u as=0.26p ps=1.52u w=1u l=0.28u
R0 VSS.n2 VSS.t0 5.2398
R1 VSS.n4 VSS.t5 4.9685
R2 VSS.n2 VSS.n1 3.3618
R3 VSS.n3 VSS.n0 3.34224
R4 VSS.n1 VSS.t4 1.6385
R5 VSS.n1 VSS.t1 1.6385
R6 VSS.n0 VSS.t2 1.6385
R7 VSS.n0 VSS.t3 1.6385
R8 VSS.n3 VSS.n2 0.2405
R9 VSS.n4 VSS.n3 0.2405
R10 VSS VSS.n4 0.0485
R11 Y.n8 Y.n3 6.51376
R12 Y Y.n0 6.33963
R13 Y.n6 Y.n5 6.3005
R14 Y.n8 Y.n2 2.93702
R15 Y.n9 Y.n1 2.92528
R16 Y.n7 Y.n4 2.84091
R17 Y.n5 Y.t0 1.6385
R18 Y.n5 Y.t6 1.6385
R19 Y.n0 Y.t3 1.6385
R20 Y.n0 Y.t11 1.6385
R21 Y.n3 Y.t1 1.6385
R22 Y.n3 Y.t2 1.6385
R23 Y.n4 Y.t5 1.31934
R24 Y.n4 Y.t4 1.31934
R25 Y.n1 Y.t8 1.31934
R26 Y.n1 Y.t9 1.31934
R27 Y.n2 Y.t10 1.31934
R28 Y.n2 Y.t7 1.31934
R29 Y.n8 Y.n7 0.581587
R30 Y.n9 Y.n8 0.536587
R31 Y.n7 Y.n6 0.16324
R32 Y Y.n9 0.146587
R33 Y.n6 Y 0.0424178
R34 VDD.n4 VDD.t4 4.1776
R35 VDD.n2 VDD.t1 3.57833
R36 VDD.n3 VDD.n0 2.8705
R37 VDD.n2 VDD.n1 2.01949
R38 VDD.n0 VDD.t2 1.31934
R39 VDD.n0 VDD.t3 1.31934
R40 VDD.n1 VDD.t0 1.31934
R41 VDD.n1 VDD.t5 1.31934
R42 VDD.n3 VDD.n2 0.2405
R43 VDD.n4 VDD.n3 0.2405
R44 VDD VDD.n4 0.0485
R45 A.n6 A.t10 27.5059
R46 A.n9 A.t11 27.0187
R47 A.n0 A.t6 26.8541
R48 A.n1 A.t7 26.8541
R49 A.n0 A.t0 26.5934
R50 A.n1 A.t1 26.5934
R51 A.n2 A.t2 26.5934
R52 A.n5 A.t3 25.9416
R53 A.n3 A.t8 24.638
R54 A.n4 A.t9 24.638
R55 A.n7 A.t4 24.5076
R56 A.n8 A.t5 23.4442
R57 A.n1 A.n0 16.5048
R58 A.n2 A.n1 16.5048
R59 A.n4 A.n3 12.2457
R60 A.n6 A.n5 12.2457
R61 A.n8 A.n7 12.2457
R62 A A.n9 8.07704
R63 A.n5 A.n4 2.86836
R64 A.n3 A.n2 2.21657
R65 A.n7 A.n6 1.43443
R66 A.n9 A.n8 0.480763
R67 VNW.t4 VNW.t5 310.079
R68 VNW.t3 VNW.t4 310.079
R69 VNW.t2 VNW.t3 310.079
R70 VNW.t1 VNW.t2 310.079
R71 VNW.t0 VNW.t1 310.079
R72 VNW VNW.t0 259.69
R73 VPW.t4 VPW.t5 1181.82
R74 VPW.t3 VPW.t4 1181.82
R75 VPW.t2 VPW.t3 1181.82
R76 VPW.t1 VPW.t2 1181.82
R77 VPW.t0 VPW.t1 1181.82
R78 VPW VPW.t0 989.774
C0 Y VNW 0.07013f
C1 VSS VNW 0.00569f
C2 VNW A 0.53132f
C3 Y VSS 0.41011f
C4 Y A 0.38406f
C5 VSS A 0.20457f
C6 VDD VNW 0.21527f
C7 VDD Y 0.94965f
C8 VDD VSS 0.03297f
C9 VDD A 0.23572f
C10 VSS VPW 0.46534f
C11 Y VPW 0.12524f
C12 VDD VPW 0.35259f
C13 A VPW 0.75292f
C14 VNW VPW 2.10378f
C15 VNW.t5 VPW 0.2177f
C16 VNW.t4 VPW 0.10185f
C17 VNW.t3 VPW 0.10185f
C18 VNW.t2 VPW 0.10185f
C19 VNW.t1 VPW 0.10185f
C20 VNW.t0 VPW 0.09357f
C21 A.t11 VPW 0.06552f
C22 A.t8 VPW 0.06202f
C23 A.t6 VPW 0.06482f
C24 A.t0 VPW 0.05199f
C25 A.n0 VPW 0.08151f
C26 A.t7 VPW 0.06482f
C27 A.t1 VPW 0.05199f
C28 A.n1 VPW 0.09556f
C29 A.t2 VPW 0.05199f
C30 A.n2 VPW 0.05041f
C31 A.n3 VPW 0.05283f
C32 A.t9 VPW 0.06202f
C33 A.n4 VPW 0.05366f
C34 A.t3 VPW 0.05116f
C35 A.n5 VPW 0.0553f
C36 A.t10 VPW 0.06564f
C37 A.n6 VPW 0.05547f
C38 A.t4 VPW 0.04935f
C39 A.n7 VPW 0.05168f
C40 A.t5 VPW 0.04841f
C41 A.n8 VPW 0.05557f
C42 A.n9 VPW 0.04268f
C43 VDD.t4 VPW 0.0929f
C44 VDD.t2 VPW 0.03433f
C45 VDD.t3 VPW 0.03433f
C46 VDD.n0 VPW 0.07273f
C47 VDD.t0 VPW 0.03433f
C48 VDD.t5 VPW 0.03433f
C49 VDD.n1 VPW 0.07539f
C50 VDD.t1 VPW 0.13063f
C51 VDD.n2 VPW 0.47903f
C52 VDD.n3 VPW 0.23799f
C53 VDD.n4 VPW 0.18923f
C54 Y.t3 VPW 0.03681f
C55 Y.t11 VPW 0.03681f
C56 Y.n0 VPW 0.0737f
C57 Y.t8 VPW 0.05079f
C58 Y.t9 VPW 0.05079f
C59 Y.n1 VPW 0.10931f
C60 Y.t10 VPW 0.05079f
C61 Y.t7 VPW 0.05079f
C62 Y.n2 VPW 0.1092f
C63 Y.t1 VPW 0.03681f
C64 Y.t2 VPW 0.03681f
C65 Y.n3 VPW 0.07456f
C66 Y.t5 VPW 0.05079f
C67 Y.t4 VPW 0.05079f
C68 Y.n4 VPW 0.11101f
C69 Y.t0 VPW 0.03681f
C70 Y.t6 VPW 0.03681f
C71 Y.n5 VPW 0.07361f
C72 Y.n6 VPW 0.04289f
C73 Y.n7 VPW 0.23475f
C74 Y.n8 VPW 0.22539f
C75 Y.n9 VPW 0.1803f
C76 VSS.t5 VPW 0.03523f
C77 VSS.t2 VPW 0.01333f
C78 VSS.t3 VPW 0.01333f
C79 VSS.n0 VPW 0.02758f
C80 VSS.t4 VPW 0.01333f
C81 VSS.t1 VPW 0.01333f
C82 VSS.n1 VPW 0.02787f
C83 VSS.t0 VPW 0.05201f
C84 VSS.n2 VPW 0.23703f
C85 VSS.n3 VPW 0.11952f
C86 VSS.n4 VPW 0.09096f
.ends

* NGSPICE file created from gf180mcu_as_sc_mcu7t3v3__invz_2.ext - technology: gf180mcuD

.subckt gf180mcu_as_sc_mcu7t3v3__invz_2 VDD VNW VPW VSS EN A Y
X0 VDD.t5 a_428_440# Y.t3 VNW.t4 pfet_03v3 ad=0.6693p pd=2.35u as=0.4623p ps=2.05u w=1.38u l=0.28u
X1 a_428_440# EN.t2 VDD.t2 VNW.t6 pfet_03v3 ad=0.3864p pd=1.94u as=0.69p ps=2.38u w=1.38u l=0.28u
X2 a_848_348# A.t0 VSS.t1 VPW.t2 nfet_03v3 ad=0.52p pd=3.04u as=0.36p ps=1.72u w=1u l=0.28u
X3 VSS.t3 EN.t1 a_28_68# VPW.t5 nfet_03v3 ad=0.26p pd=1.52u as=0.44p ps=2.88u w=1u l=0.28u
X4 Y.t0 a_332_68# VSS.t4 VPW.t3 nfet_03v3 ad=0.61p pd=2.22u as=0.27p ps=1.54u w=1u l=0.28u
X5 Y.t2 a_428_440# VDD.t4 VNW.t3 pfet_03v3 ad=0.4623p pd=2.05u as=0.6348p ps=2.3u w=1.38u l=0.28u
X6 a_848_348# A.t1 VDD.t1 VNW.t2 pfet_03v3 ad=0.7176p pd=3.8u as=0.6693p ps=2.35u w=1.38u l=0.28u
X7 VSS.t5 a_332_68# Y.t1 VPW.t4 nfet_03v3 ad=0.36p pd=1.72u as=0.61p ps=2.22u w=1u l=0.28u
X8 a_428_440# EN.t0 a_332_68# VPW.t6 nfet_03v3 ad=1.52p pd=5.04u as=0.26p ps=1.52u w=1u l=0.28u
X9 VSS.t0 a_848_348# a_332_68# VPW.t0 nfet_03v3 ad=0.27p pd=1.54u as=0.44p ps=2.88u w=1u l=0.28u
X10 a_332_68# a_28_68# a_428_440# VNW.t1 pfet_03v3 ad=0.6072p pd=3.64u as=0.3864p ps=1.94u w=1.38u l=0.28u
X11 VDD.t3 EN.t3 a_28_68# VNW.t5 pfet_03v3 ad=0.69p pd=2.38u as=0.6072p ps=3.64u w=1.38u l=0.28u
X12 VDD.t0 a_848_348# a_428_440# VNW.t0 pfet_03v3 ad=0.6348p pd=2.3u as=1.2351p ps=4.55u w=1.38u l=0.28u
X13 a_332_68# a_28_68# VSS.t2 VPW.t1 nfet_03v3 ad=0.26p pd=1.52u as=0.26p ps=1.52u w=1u l=0.28u
R0 VSS.n4 VSS.n0 6.41007
R1 VSS.n3 VSS.n1 6.35874
R2 VSS.n3 VSS.n2 3.73289
R3 VSS.n2 VSS.t5 2.8985
R4 VSS.n1 VSS.t0 1.7645
R5 VSS.n2 VSS.t1 1.6385
R6 VSS.n1 VSS.t4 1.6385
R7 VSS.n0 VSS.t2 1.6385
R8 VSS.n0 VSS.t3 1.6385
R9 VSS.n4 VSS.n3 0.6215
R10 VSS VSS.n4 0.1685
R11 Y.n3 Y.n2 6.3005
R12 Y.n1 Y.n0 5.24614
R13 Y.n2 Y.t0 5.1035
R14 Y.n2 Y.t1 2.5835
R15 Y.n0 Y.t2 2.02949
R16 Y.n0 Y.t3 1.37007
R17 Y.n4 Y.n1 0.212265
R18 Y.n1 Y 0.159929
R19 Y Y.n4 0.116971
R20 Y.n4 Y.n3 0.0485
R21 Y.n3 Y 0.0185
R22 VDD.n3 VDD.n2 5.68148
R23 VDD.n4 VDD.n0 5.31985
R24 VDD.n3 VDD.n1 5.31398
R25 VDD.n2 VDD.t5 3.34833
R26 VDD.n0 VDD.t2 3.24688
R27 VDD.n1 VDD.t4 2.84108
R28 VDD.n0 VDD.t3 1.82659
R29 VDD.n1 VDD.t0 1.82659
R30 VDD.n2 VDD.t1 1.57296
R31 VDD.n4 VDD.n3 0.6065
R32 VDD VDD.n4 0.1835
R33 A.n0 A.t1 26.4485
R34 A.n0 A.t0 24.1021
R35 A A.n0 8.302
R36 EN.n0 EN.t3 27.1385
R37 EN.n1 EN.t2 24.5778
R38 EN.n0 EN.t1 23.7492
R39 EN.n1 EN.t0 22.0453
R40 EN.n2 EN.n1 8.32609
R41 EN.n2 EN.n0 8.06898
R42 EN EN.n2 0.0222895
R43 VNW.t1 VNW.t0 744.187
R44 VNW.t5 VNW.t6 496.125
R45 VNW.t4 VNW.t2 484.497
R46 VNW.t0 VNW.t3 465.116
R47 VNW.t3 VNW.t4 368.217
R48 VNW.t6 VNW.t1 325.582
R49 VNW VNW.t5 259.69
R50 VPW.t6 VPW.t0 3722.73
R51 VPW.t3 VPW.t4 2215.91
R52 VPW.t4 VPW.t2 1477.27
R53 VPW.t0 VPW.t3 1211.36
R54 VPW.t1 VPW.t6 1181.82
R55 VPW.t5 VPW.t1 1181.82
R56 VPW VPW.t5 989.774
C0 Y a_332_68# 0.37288f
C1 Y VDD 0.01213f
C2 Y a_848_348# 0.28044f
C3 VNW EN 0.18577f
C4 a_428_440# VSS 0.0128f
C5 VSS a_28_68# 0.13243f
C6 a_332_68# VSS 1.45334f
C7 VSS VDD 0.00607f
C8 VSS a_848_348# 0.07212f
C9 a_428_440# a_28_68# 0.1854f
C10 a_428_440# a_332_68# 0.89397f
C11 a_332_68# a_28_68# 0.32917f
C12 a_428_440# VDD 0.48529f
C13 a_428_440# a_848_348# 0.72711f
C14 a_28_68# VDD 0.26177f
C15 a_28_68# a_848_348# 0.00576f
C16 VNW A 0.0958f
C17 a_332_68# VDD 0.00494f
C18 a_332_68# a_848_348# 0.07123f
C19 VDD a_848_348# 0.79374f
C20 VSS EN 0.03099f
C21 VNW Y 0.00773f
C22 a_428_440# EN 0.006f
C23 EN a_28_68# 0.9259f
C24 Y A 0.10037f
C25 a_332_68# EN 0.06466f
C26 EN VDD 0.04245f
C27 VNW VSS 0.00516f
C28 EN a_848_348# 0.00309f
C29 VSS A 0.04918f
C30 VNW a_428_440# 0.22948f
C31 VNW a_28_68# 0.14009f
C32 VNW a_332_68# 0.08554f
C33 VNW VDD 0.20769f
C34 a_428_440# A 0.0101f
C35 VNW a_848_348# 0.14887f
C36 a_332_68# A 0.1388f
C37 A VDD 0.02634f
C38 A a_848_348# 0.42068f
C39 Y VSS 0.0095f
C40 Y a_428_440# 0.2027f
C41 VSS VPW 0.67495f
C42 Y VPW -0.13642f
C43 VDD VPW 0.45802f
C44 A VPW 0.42727f
C45 EN VPW 0.23728f
C46 VNW VPW 3.13207f
C47 a_332_68# VPW 0.25297f
C48 a_428_440# VPW 0.10961f
C49 a_848_348# VPW 0.19942f
C50 a_28_68# VPW 0.20399f
C51 VNW.t2 VPW 0.20895f
C52 VNW.t4 VPW 0.12391f
C53 VNW.t3 VPW 0.12109f
C54 VNW.t0 VPW 0.17572f
C55 VNW.t1 VPW 0.15545f
C56 VNW.t6 VPW 0.1194f
C57 VNW.t5 VPW 0.10983f
C58 EN.t3 VPW 0.13498f
C59 EN.t1 VPW 0.10063f
C60 EN.n0 VPW 0.16174f
C61 EN.t2 VPW 0.13484f
C62 EN.t0 VPW 0.1028f
C63 EN.n1 VPW 0.19421f
C64 EN.n2 VPW 0.41647f
C65 A.t1 VPW 0.17286f
C66 A.t0 VPW 0.13179f
C67 A.n0 VPW 0.22029f
C68 VDD.t2 VPW 0.08392f
C69 VDD.t3 VPW 0.0472f
C70 VDD.n0 VPW 0.13143f
C71 VDD.t4 VPW 0.07343f
C72 VDD.t0 VPW 0.0472f
C73 VDD.n1 VPW 0.12092f
C74 VDD.t1 VPW 0.04065f
C75 VDD.t5 VPW 0.08654f
C76 VDD.n2 VPW 0.14701f
C77 VDD.n3 VPW 0.67225f
C78 VDD.n4 VPW 0.3203f
C79 Y.t3 VPW 0.05818f
C80 Y.t2 VPW 0.08619f
C81 Y.n0 VPW 0.14532f
C82 Y.n1 VPW 0.32569f
C83 Y.t1 VPW 0.06402f
C84 Y.t0 VPW 0.12648f
C85 Y.n2 VPW 0.19049f
C86 Y.n3 VPW 0.04122f
C87 Y.n4 VPW 0.09581f
C88 VSS.t2 VPW 0.03034f
C89 VSS.t3 VPW 0.03034f
C90 VSS.n0 VPW 0.06096f
C91 VSS.t4 VPW 0.03034f
C92 VSS.t0 VPW 0.03267f
C93 VSS.n1 VPW 0.06317f
C94 VSS.t1 VPW 0.03034f
C95 VSS.t5 VPW 0.05367f
C96 VSS.n2 VPW 0.12564f
C97 VSS.n3 VPW 0.84364f
C98 VSS.n4 VPW 0.3921f
.ends

* NGSPICE file created from gf180mcu_as_sc_mcu7t3v3__maj3_2.ext - technology: gf180mcuD

.subckt gf180mcu_as_sc_mcu7t3v3__maj3_2 VDD VNW VPW VSS Y A B C
X0 a_436_68# B.t0 VSS.t0 VPW.t5 nfet_03v3 ad=0.12p pd=1.24u as=0.26p ps=1.52u w=1u l=0.28u
X1 VSS.t3 A.t0 a_700_68# VPW.t7 nfet_03v3 ad=0.26p pd=1.52u as=0.12p ps=1.24u w=1u l=0.28u
X2 Y.t0 a_28_68# VDD.t2 VNW.t0 pfet_03v3 ad=0.4485p pd=2.03u as=0.3588p ps=1.9u w=1.38u l=0.28u
X3 a_172_68# A.t1 a_28_68# VPW.t6 nfet_03v3 ad=0.12p pd=1.24u as=0.44p ps=2.88u w=1u l=0.28u
X4 VSS.t1 a_28_68# Y.t3 VPW.t1 nfet_03v3 ad=0.83p pd=3.66u as=0.325p ps=1.65u w=1u l=0.28u
X5 VSS.t4 B.t1 a_172_68# VPW.t4 nfet_03v3 ad=0.26p pd=1.52u as=0.12p ps=1.24u w=1u l=0.28u
X6 VDD.t0 B.t3 a_172_440# VNW.t4 pfet_03v3 ad=0.3588p pd=1.9u as=0.1656p ps=1.62u w=1.38u l=0.28u
X7 a_700_440# C.t2 a_28_68# VNW.t3 pfet_03v3 ad=0.1656p pd=1.62u as=0.3588p ps=1.9u w=1.38u l=0.28u
X8 a_700_68# C.t0 a_28_68# VPW.t3 nfet_03v3 ad=0.12p pd=1.24u as=0.26p ps=1.52u w=1u l=0.28u
X9 a_436_440# B.t2 VDD.t1 VNW.t5 pfet_03v3 ad=0.1656p pd=1.62u as=0.3588p ps=1.9u w=1.38u l=0.28u
X10 a_28_68# C.t1 a_436_68# VPW.t2 nfet_03v3 ad=0.26p pd=1.52u as=0.12p ps=1.24u w=1u l=0.28u
X11 VDD.t4 A.t2 a_700_440# VNW.t7 pfet_03v3 ad=0.3588p pd=1.9u as=0.1656p ps=1.62u w=1.38u l=0.28u
X12 Y.t2 a_28_68# VSS.t2 VPW.t0 nfet_03v3 ad=0.325p pd=1.65u as=0.26p ps=1.52u w=1u l=0.28u
X13 a_28_68# C.t3 a_436_440# VNW.t2 pfet_03v3 ad=0.3588p pd=1.9u as=0.1656p ps=1.62u w=1.38u l=0.28u
X14 a_172_440# A.t3 a_28_68# VNW.t6 pfet_03v3 ad=0.1656p pd=1.62u as=0.6072p ps=3.64u w=1.38u l=0.28u
X15 VDD.t3 a_28_68# Y.t1 VNW.t1 pfet_03v3 ad=1.1454p pd=4.42u as=0.4485p ps=2.03u w=1.38u l=0.28u
R0 VSS.n2 VSS.n1 6.38659
R1 VSS.n3 VSS.n0 6.38659
R2 VSS.n2 VSS.t1 5.2593
R3 VSS.n1 VSS.t2 1.6385
R4 VSS.n1 VSS.t3 1.6385
R5 VSS.n0 VSS.t0 1.6385
R6 VSS.n0 VSS.t4 1.6385
R7 VSS.n3 VSS.n2 0.3965
R8 VSS VSS.n3 0.2465
R9 Y.n2 Y.n1 6.3005
R10 Y.n2 Y.n0 2.97417
R11 Y.n1 Y.t2 2.4575
R12 Y.n0 Y.t0 1.97876
R13 Y.n1 Y.t3 1.6385
R14 Y.n0 Y.t1 1.31934
R15 Y Y.n2 0.0415127
R16 VDD.n3 VDD.n0 5.28659
R17 VDD.n2 VDD.n1 5.28659
R18 VDD.n2 VDD.t3 3.59783
R19 VDD.n0 VDD.t1 1.31934
R20 VDD.n0 VDD.t0 1.31934
R21 VDD.n1 VDD.t2 1.31934
R22 VDD.n1 VDD.t4 1.31934
R23 VDD.n3 VDD.n2 0.3965
R24 VDD VDD.n3 0.2465
R25 C.n0 C.t2 24.5076
R26 C.n1 C.t3 24.5076
R27 C.n0 C.t0 19.5541
R28 C.n1 C.t1 19.5541
R29 C.n2 C.n0 8.11161
R30 C.n2 C.n1 8.11161
R31 C C.n2 4.13936
R32 B.n0 B.t2 24.3773
R33 B.n1 B.t3 24.3773
R34 B.n0 B.t0 19.6844
R35 B.n1 B.t1 19.6844
R36 B.n2 B.n0 8.71994
R37 B.n2 B.n1 7.50328
R38 B B.n2 4.13354
R39 A.n0 A.t2 27.518
R40 A.n1 A.t3 27.1618
R41 A.n0 A.t0 22.6099
R42 A.n1 A.t1 22.2633
R43 A.n2 A.n0 9.54283
R44 A.n2 A.n1 8.0005
R45 A A.n2 0.0353387
R46 VNW.t0 VNW.t1 360.466
R47 VNW.t7 VNW.t0 310.079
R48 VNW.t2 VNW.t3 310.079
R49 VNW.t4 VNW.t5 310.079
R50 VNW VNW.t6 259.69
R51 VNW.t3 VNW.t7 201.55
R52 VNW.t5 VNW.t2 201.55
R53 VNW.t6 VNW.t4 201.55
R54 VPW.t0 VPW.t1 1373.86
R55 VPW.t7 VPW.t0 1181.82
R56 VPW.t2 VPW.t3 1181.82
R57 VPW.t4 VPW.t5 1181.82
R58 VPW VPW.t6 989.774
R59 VPW.t3 VPW.t7 768.183
R60 VPW.t5 VPW.t2 768.183
R61 VPW.t6 VPW.t4 768.183
C0 Y a_28_68# 0.5082f
C1 VDD a_28_68# 0.4958f
C2 A a_172_440# 0.00294f
C3 a_172_440# Y 0
C4 VDD a_172_440# 0.00351f
C5 A a_700_68# 0
C6 VSS a_700_68# 0.00445f
C7 VNW a_28_68# 0.19314f
C8 C A 0.38983f
C9 C VSS 0.02745f
C10 C B 0.12764f
C11 C Y 0
C12 a_436_68# a_28_68# 0.00523f
C13 C VDD 0.02676f
C14 VSS A 0.0274f
C15 A B 0.39001f
C16 VSS B 0.03043f
C17 A Y 0
C18 VSS Y 0.09063f
C19 B Y 0
C20 a_436_440# a_28_68# 0.00611f
C21 A VDD 0.03515f
C22 VSS VDD 0.03825f
C23 B VDD 0.02822f
C24 VDD Y 0.2606f
C25 a_28_68# a_172_68# 0.0054f
C26 C VNW 0.13919f
C27 VNW A 0.16847f
C28 VSS VNW 0.00641f
C29 VNW B 0.13915f
C30 a_700_440# a_28_68# 0.00659f
C31 VNW Y 0.02011f
C32 VNW VDD 0.19053f
C33 A a_436_68# 0
C34 VSS a_436_68# 0.00429f
C35 A a_436_440# 0.00294f
C36 Y a_436_440# 0
C37 a_172_440# a_28_68# 0.00608f
C38 VDD a_436_440# 0.00413f
C39 A a_172_68# 0
C40 VSS a_172_68# 0.0036f
C41 a_700_68# a_28_68# 0.00539f
C42 C a_28_68# 0.1653f
C43 A a_700_440# 0.00294f
C44 a_700_440# Y 0
C45 VDD a_700_440# 0.00413f
C46 A a_28_68# 0.73251f
C47 VSS a_28_68# 0.49038f
C48 B a_28_68# 0.15354f
C49 VSS VPW 0.53606f
C50 Y VPW 0.03834f
C51 VDD VPW 0.41812f
C52 C VPW 0.32212f
C53 B VPW 0.30939f
C54 A VPW 0.24493f
C55 VNW VPW 2.43891f
C56 a_28_68# VPW 0.27085f
C57 VNW.t1 VPW 0.22669f
C58 VNW.t0 VPW 0.0978f
C59 VNW.t7 VPW 0.07462f
C60 VNW.t3 VPW 0.07462f
C61 VNW.t2 VPW 0.07462f
C62 VNW.t5 VPW 0.07462f
C63 VNW.t4 VPW 0.07462f
C64 VNW.t6 VPW 0.06727f
C65 A.t2 VPW 0.1738f
C66 A.t0 VPW 0.12501f
C67 A.n0 VPW 0.27008f
C68 A.t3 VPW 0.1729f
C69 A.t1 VPW 0.12419f
C70 A.n1 VPW 0.23224f
C71 A.n2 VPW 0.63078f
C72 B.t2 VPW 0.10874f
C73 B.t0 VPW 0.07626f
C74 B.n0 VPW 0.15095f
C75 B.t3 VPW 0.10874f
C76 B.t1 VPW 0.07626f
C77 B.n1 VPW 0.14648f
C78 B.n2 VPW 0.06306f
C79 C.t2 VPW 0.10819f
C80 C.t0 VPW 0.07539f
C81 C.n0 VPW 0.14757f
C82 C.t3 VPW 0.10819f
C83 C.t1 VPW 0.07539f
C84 C.n1 VPW 0.14757f
C85 C.n2 VPW 0.0631f
C86 VDD.t1 VPW 0.02732f
C87 VDD.t0 VPW 0.02732f
C88 VDD.n0 VPW 0.0548f
C89 VDD.t2 VPW 0.02732f
C90 VDD.t4 VPW 0.02732f
C91 VDD.n1 VPW 0.0548f
C92 VDD.t3 VPW 0.13785f
C93 VDD.n2 VPW 0.44636f
C94 VDD.n3 VPW 0.20904f
C95 Y.t1 VPW 0.06334f
C96 Y.t0 VPW 0.09501f
C97 Y.n0 VPW 0.18306f
C98 Y.t3 VPW 0.0459f
C99 Y.t2 VPW 0.06885f
C100 Y.n1 VPW 0.11475f
C101 Y.n2 VPW 0.29884f
C102 VSS.t0 VPW 0.01485f
C103 VSS.t4 VPW 0.01485f
C104 VSS.n0 VPW 0.0298f
C105 VSS.t2 VPW 0.01485f
C106 VSS.t3 VPW 0.01485f
C107 VSS.n1 VPW 0.0298f
C108 VSS.t1 VPW 0.07751f
C109 VSS.n2 VPW 0.31371f
C110 VSS.n3 VPW 0.15684f
.ends

* NGSPICE file created from gf180mcu_as_sc_mcu7t3v3__maj3_4.ext - technology: gf180mcuD

.subckt gf180mcu_as_sc_mcu7t3v3__maj3_4 VDD VNW VPW VSS Y A B C
X0 Y.t6 a_28_68# VSS.t3 VPW.t4 nfet_03v3 ad=0.26p pd=1.52u as=0.26p ps=1.52u w=1u l=0.28u
X1 a_436_68# B.t0 VSS.t2 VPW.t7 nfet_03v3 ad=0.12p pd=1.24u as=0.26p ps=1.52u w=1u l=0.28u
X2 VSS.t0 A.t0 a_700_68# VPW.t9 nfet_03v3 ad=0.26p pd=1.52u as=0.12p ps=1.24u w=1u l=0.28u
X3 Y.t3 a_28_68# VDD.t3 VNW.t2 pfet_03v3 ad=0.4485p pd=2.03u as=0.3588p ps=1.9u w=1.38u l=0.28u
X4 a_172_68# A.t1 a_28_68# VPW.t8 nfet_03v3 ad=0.12p pd=1.24u as=0.44p ps=2.88u w=1u l=0.28u
X5 VSS.t4 a_28_68# Y.t5 VPW.t3 nfet_03v3 ad=0.26p pd=1.52u as=0.325p ps=1.65u w=1u l=0.28u
X6 VSS.t1 B.t1 a_172_68# VPW.t6 nfet_03v3 ad=0.26p pd=1.52u as=0.12p ps=1.24u w=1u l=0.28u
X7 VDD.t2 B.t3 a_172_440# VNW.t6 pfet_03v3 ad=0.3588p pd=1.9u as=0.1656p ps=1.62u w=1.38u l=0.28u
X8 a_700_440# C.t2 a_28_68# VNW.t1 pfet_03v3 ad=0.1656p pd=1.62u as=0.3588p ps=1.9u w=1.38u l=0.28u
X9 Y.t0 a_28_68# VDD.t5 VNW.t4 pfet_03v3 ad=0.3588p pd=1.9u as=0.3588p ps=1.9u w=1.38u l=0.28u
X10 a_700_68# C.t0 a_28_68# VPW.t1 nfet_03v3 ad=0.12p pd=1.24u as=0.26p ps=1.52u w=1u l=0.28u
X11 a_436_440# B.t2 VDD.t0 VNW.t7 pfet_03v3 ad=0.1656p pd=1.62u as=0.3588p ps=1.9u w=1.38u l=0.28u
X12 a_28_68# C.t1 a_436_68# VPW.t0 nfet_03v3 ad=0.26p pd=1.52u as=0.12p ps=1.24u w=1u l=0.28u
X13 VDD.t1 A.t2 a_700_440# VNW.t9 pfet_03v3 ad=0.3588p pd=1.9u as=0.1656p ps=1.62u w=1.38u l=0.28u
X14 VDD.t6 a_28_68# Y.t1 VNW.t5 pfet_03v3 ad=0.8211p pd=3.95u as=0.3588p ps=1.9u w=1.38u l=0.28u
X15 VSS.t5 a_28_68# Y.t7 VPW.t5 nfet_03v3 ad=0.575p pd=3.15u as=0.26p ps=1.52u w=1u l=0.28u
X16 Y.t4 a_28_68# VSS.t6 VPW.t2 nfet_03v3 ad=0.325p pd=1.65u as=0.26p ps=1.52u w=1u l=0.28u
X17 a_28_68# C.t3 a_436_440# VNW.t0 pfet_03v3 ad=0.3588p pd=1.9u as=0.1656p ps=1.62u w=1.38u l=0.28u
X18 a_172_440# A.t3 a_28_68# VNW.t8 pfet_03v3 ad=0.1656p pd=1.62u as=0.6072p ps=3.64u w=1.38u l=0.28u
X19 VDD.t4 a_28_68# Y.t2 VNW.t3 pfet_03v3 ad=0.3588p pd=1.9u as=0.4485p ps=2.03u w=1.38u l=0.28u
R0 VSS.n4 VSS.n1 6.38659
R1 VSS.n5 VSS.n0 6.38659
R2 VSS.n3 VSS.t5 5.2398
R3 VSS.n3 VSS.n2 3.3618
R4 VSS.n2 VSS.t3 1.6385
R5 VSS.n2 VSS.t4 1.6385
R6 VSS.n1 VSS.t6 1.6385
R7 VSS.n1 VSS.t0 1.6385
R8 VSS.n0 VSS.t2 1.6385
R9 VSS.n0 VSS.t1 1.6385
R10 VSS.n5 VSS.n4 0.3965
R11 VSS.n4 VSS.n3 0.26
R12 VSS VSS.n5 0.2465
R13 Y.n7 Y.n6 6.3005
R14 Y.n3 Y.n2 6.3005
R15 Y.n4 Y.n1 2.91474
R16 Y.n5 Y.n0 2.83518
R17 Y.n6 Y.t4 2.4575
R18 Y.n0 Y.t3 1.97876
R19 Y.n2 Y.t7 1.6385
R20 Y.n2 Y.t6 1.6385
R21 Y.n6 Y.t5 1.6385
R22 Y.n1 Y.t1 1.31934
R23 Y.n1 Y.t0 1.31934
R24 Y.n0 Y.t2 1.31934
R25 Y.n5 Y.n4 0.472022
R26 Y.n4 Y.n3 0.186602
R27 Y.n7 Y.n5 0.139487
R28 Y.n3 Y 0.0554153
R29 Y Y.n7 0.0415127
R30 VDD.n5 VDD.n0 5.28659
R31 VDD.n4 VDD.n1 5.28659
R32 VDD.n3 VDD.t6 3.57833
R33 VDD.n3 VDD.n2 2.01949
R34 VDD.n0 VDD.t0 1.31934
R35 VDD.n0 VDD.t2 1.31934
R36 VDD.n1 VDD.t3 1.31934
R37 VDD.n1 VDD.t1 1.31934
R38 VDD.n2 VDD.t5 1.31934
R39 VDD.n2 VDD.t4 1.31934
R40 VDD.n5 VDD.n4 0.3965
R41 VDD.n4 VDD.n3 0.26
R42 VDD VDD.n5 0.2465
R43 C.n0 C.t2 24.5076
R44 C.n1 C.t3 24.5076
R45 C.n0 C.t0 19.5541
R46 C.n1 C.t1 19.5541
R47 C.n2 C.n0 8.11161
R48 C.n2 C.n1 8.11161
R49 C C.n2 4.13936
R50 B.n0 B.t2 24.3773
R51 B.n1 B.t3 24.3773
R52 B.n0 B.t0 19.6844
R53 B.n1 B.t1 19.6844
R54 B.n2 B.n0 8.71994
R55 B.n2 B.n1 7.50328
R56 B B.n2 4.13354
R57 A.n0 A.t2 27.518
R58 A.n1 A.t3 27.1618
R59 A.n0 A.t0 22.6099
R60 A.n1 A.t1 22.2633
R61 A.n2 A.n0 9.54283
R62 A.n2 A.n1 8.0005
R63 A A.n2 0.0353387
R64 VNW.t2 VNW.t3 360.466
R65 VNW.t4 VNW.t5 310.079
R66 VNW.t3 VNW.t4 310.079
R67 VNW.t9 VNW.t2 310.079
R68 VNW.t0 VNW.t1 310.079
R69 VNW.t6 VNW.t7 310.079
R70 VNW VNW.t8 259.69
R71 VNW.t1 VNW.t9 201.55
R72 VNW.t7 VNW.t0 201.55
R73 VNW.t8 VNW.t6 201.55
R74 VPW.t2 VPW.t3 1373.86
R75 VPW.t4 VPW.t5 1181.82
R76 VPW.t3 VPW.t4 1181.82
R77 VPW.t9 VPW.t2 1181.82
R78 VPW.t0 VPW.t1 1181.82
R79 VPW.t6 VPW.t7 1181.82
R80 VPW VPW.t8 989.774
R81 VPW.t1 VPW.t9 768.183
R82 VPW.t7 VPW.t0 768.183
R83 VPW.t8 VPW.t6 768.183
C0 C Y 0
C1 a_28_68# VSS 0.54508f
C2 a_436_440# VDD 0.00413f
C3 C A 0.38983f
C4 a_28_68# VDD 0.55489f
C5 a_436_440# a_28_68# 0.00611f
C6 a_172_68# VSS 0.0036f
C7 VNW Y 0.03975f
C8 B Y 0
C9 VSS Y 0.27528f
C10 VNW A 0.16847f
C11 A B 0.39001f
C12 A a_700_68# 0
C13 a_436_68# VSS 0.00429f
C14 A VSS 0.0274f
C15 a_700_440# VDD 0.00413f
C16 a_172_68# a_28_68# 0.0054f
C17 a_172_440# VDD 0.00351f
C18 VDD Y 0.63522f
C19 a_436_440# Y 0
C20 a_700_440# a_28_68# 0.00659f
C21 A VDD 0.03515f
C22 a_172_440# a_28_68# 0.00608f
C23 A a_436_440# 0.00294f
C24 a_28_68# Y 0.60713f
C25 a_436_68# a_28_68# 0.00523f
C26 A a_28_68# 0.73251f
C27 C VNW 0.13919f
C28 C B 0.12764f
C29 C VSS 0.02745f
C30 C VDD 0.02676f
C31 a_172_68# A 0
C32 C a_28_68# 0.1653f
C33 a_700_440# Y 0
C34 a_172_440# Y 0
C35 A a_700_440# 0.00294f
C36 A a_172_440# 0.00294f
C37 A Y 0
C38 VNW B 0.13915f
C39 VNW VSS 0.00896f
C40 A a_436_68# 0
C41 B VSS 0.03043f
C42 VSS a_700_68# 0.00445f
C43 VNW VDD 0.25329f
C44 B VDD 0.02822f
C45 VSS VDD 0.03764f
C46 VNW a_28_68# 0.36873f
C47 B a_28_68# 0.15354f
C48 a_28_68# a_700_68# 0.00539f
C49 VSS VPW 0.6473f
C50 Y VPW 0.05627f
C51 VDD VPW 0.49358f
C52 C VPW 0.32212f
C53 B VPW 0.30939f
C54 A VPW 0.24493f
C55 VNW VPW 2.96526f
C56 a_28_68# VPW 0.48282f
C57 VNW.t5 VPW 0.24378f
C58 VNW.t4 VPW 0.09655f
C59 VNW.t3 VPW 0.10439f
C60 VNW.t2 VPW 0.10439f
C61 VNW.t9 VPW 0.07965f
C62 VNW.t1 VPW 0.07965f
C63 VNW.t0 VPW 0.07965f
C64 VNW.t7 VPW 0.07965f
C65 VNW.t6 VPW 0.07965f
C66 VNW.t8 VPW 0.07181f
C67 A.t2 VPW 0.1738f
C68 A.t0 VPW 0.12501f
C69 A.n0 VPW 0.27008f
C70 A.t3 VPW 0.1729f
C71 A.t1 VPW 0.12419f
C72 A.n1 VPW 0.23224f
C73 A.n2 VPW 0.63078f
C74 B.t2 VPW 0.10874f
C75 B.t0 VPW 0.07626f
C76 B.n0 VPW 0.15095f
C77 B.t3 VPW 0.10874f
C78 B.t1 VPW 0.07626f
C79 B.n1 VPW 0.14648f
C80 B.n2 VPW 0.06306f
C81 C.t2 VPW 0.10819f
C82 C.t0 VPW 0.07539f
C83 C.n0 VPW 0.14757f
C84 C.t3 VPW 0.10819f
C85 C.t1 VPW 0.07539f
C86 C.n1 VPW 0.14757f
C87 C.n2 VPW 0.0631f
C88 VDD.t0 VPW 0.03198f
C89 VDD.t2 VPW 0.03198f
C90 VDD.n0 VPW 0.06416f
C91 VDD.t3 VPW 0.03198f
C92 VDD.t1 VPW 0.03198f
C93 VDD.n1 VPW 0.06416f
C94 VDD.t5 VPW 0.03198f
C95 VDD.t4 VPW 0.03198f
C96 VDD.n2 VPW 0.07058f
C97 VDD.t6 VPW 0.12332f
C98 VDD.n3 VPW 0.48684f
C99 VDD.n4 VPW 0.24954f
C100 VDD.n5 VPW 0.24472f
C101 Y.t2 VPW 0.05924f
C102 Y.t3 VPW 0.08886f
C103 Y.n0 VPW 0.16003f
C104 Y.t1 VPW 0.05924f
C105 Y.t0 VPW 0.05924f
C106 Y.n1 VPW 0.13009f
C107 Y.t7 VPW 0.04293f
C108 Y.t6 VPW 0.04293f
C109 Y.n2 VPW 0.08586f
C110 Y.n3 VPW 0.03848f
C111 Y.n4 VPW 0.22167f
C112 Y.n5 VPW 0.28491f
C113 Y.t5 VPW 0.04293f
C114 Y.t4 VPW 0.06439f
C115 Y.n6 VPW 0.10732f
C116 Y.n7 VPW 0.05152f
C117 VSS.t2 VPW 0.01596f
C118 VSS.t1 VPW 0.01596f
C119 VSS.n0 VPW 0.03202f
C120 VSS.t6 VPW 0.01596f
C121 VSS.t0 VPW 0.01596f
C122 VSS.n1 VPW 0.03202f
C123 VSS.t3 VPW 0.01596f
C124 VSS.t4 VPW 0.01596f
C125 VSS.n2 VPW 0.03336f
C126 VSS.t5 VPW 0.06125f
C127 VSS.n3 VPW 0.30953f
C128 VSS.n4 VPW 0.1718f
C129 VSS.n5 VPW 0.16849f
.ends

* NGSPICE file created from gf180mcu_as_sc_mcu7t3v3__mux2_2.ext - technology: gf180mcuD

.subckt gf180mcu_as_sc_mcu7t3v3__mux2_2 VDD VNW VPW VSS S B A Y
X0 a_744_440# S.t2 a_464_68# VNW.t6 pfet_03v3 ad=0.1932p pd=1.66u as=0.3588p ps=1.9u w=1.38u l=0.28u
X1 VDD.t4 A.t1 a_744_440# VNW.t0 pfet_03v3 ad=0.3588p pd=1.9u as=0.1932p ps=1.66u w=1.38u l=0.28u
X2 a_332_440# B.t1 VDD.t0 VNW.t4 pfet_03v3 ad=0.6762p pd=2.36u as=0.3588p ps=1.9u w=1.38u l=0.28u
X3 a_464_68# S.t0 a_332_68# VPW.t6 nfet_03v3 ad=0.26p pd=1.52u as=0.19p ps=1.38u w=1u l=0.28u
X4 VSS.t1 S.t1 a_28_68# VPW.t5 nfet_03v3 ad=0.26p pd=1.52u as=0.44p ps=2.88u w=1u l=0.28u
X5 Y.t0 a_464_68# VDD.t2 VNW.t2 pfet_03v3 ad=0.3726p pd=1.92u as=0.3588p ps=1.9u w=1.38u l=0.28u
X6 Y.t2 a_464_68# VSS.t2 VPW.t2 nfet_03v3 ad=0.27p pd=1.54u as=0.26p ps=1.52u w=1u l=0.28u
X7 VSS.t4 A.t0 a_624_68# VPW.t0 nfet_03v3 ad=0.26p pd=1.52u as=0.44p ps=1.88u w=1u l=0.28u
X8 VDD.t3 a_464_68# Y.t1 VNW.t3 pfet_03v3 ad=0.828p pd=3.96u as=0.3726p ps=1.92u w=1.38u l=0.28u
X9 VSS.t3 a_464_68# Y.t3 VPW.t3 nfet_03v3 ad=0.6p pd=3.2u as=0.27p ps=1.54u w=1u l=0.28u
X10 a_464_68# a_28_68# a_332_440# VNW.t1 pfet_03v3 ad=0.3588p pd=1.9u as=0.6762p ps=2.36u w=1.38u l=0.28u
X11 VDD.t1 S.t3 a_28_68# VNW.t5 pfet_03v3 ad=0.3588p pd=1.9u as=0.6072p ps=3.64u w=1.38u l=0.28u
X12 a_624_68# a_28_68# a_464_68# VPW.t1 nfet_03v3 ad=0.44p pd=1.88u as=0.26p ps=1.52u w=1u l=0.28u
X13 a_332_68# B.t0 VSS.t0 VPW.t4 nfet_03v3 ad=0.19p pd=1.38u as=0.26p ps=1.52u w=1u l=0.28u
R0 VSS.n2 VSS.n1 6.38659
R1 VSS.n3 VSS.n0 6.38659
R2 VSS.n2 VSS.t3 5.2428
R3 VSS.n1 VSS.t2 1.6385
R4 VSS.n1 VSS.t4 1.6385
R5 VSS.n0 VSS.t0 1.6385
R6 VSS.n0 VSS.t1 1.6385
R7 VSS.n3 VSS.n2 0.5135
R8 VSS VSS.n3 0.1685
R9 Y.n2 Y.n1 6.3005
R10 Y.n2 Y.n0 3.04777
R11 Y.n1 Y.t2 1.7645
R12 Y.n1 Y.t3 1.6385
R13 Y.n0 Y.t0 1.42079
R14 Y.n0 Y.t1 1.31934
R15 Y Y.n2 0.0468636
R16 VDD.n3 VDD.n0 5.28659
R17 VDD.n2 VDD.n1 5.28659
R18 VDD.n2 VDD.t3 3.58133
R19 VDD.n0 VDD.t0 1.31934
R20 VDD.n0 VDD.t1 1.31934
R21 VDD.n1 VDD.t2 1.31934
R22 VDD.n1 VDD.t4 1.31934
R23 VDD.n3 VDD.n2 0.5135
R24 VDD VDD.n3 0.1685
R25 A.n0 A.t1 27.9549
R26 A.n0 A.t0 23.0882
R27 A A.n0 8.0505
R28 B.n0 B.t1 27.332
R29 B.n0 B.t0 22.5088
R30 B B.n0 8.05423
R31 S S.t2 36.2051
R32 S.n1 S.t0 31.1981
R33 S.n0 S.t3 27.419
R34 S.n0 S.t1 22.4219
R35 S S.n0 8.05289
R36 S.n1 S 0.683326
R37 S S.n1 0.652022
R38 VNW.t4 VNW.t1 488.373
R39 VNW.t2 VNW.t3 317.829
R40 VNW.t0 VNW.t2 310.079
R41 VNW.t1 VNW.t6 310.079
R42 VNW.t5 VNW.t4 310.079
R43 VNW VNW.t5 259.69
R44 VNW.t6 VNW.t0 217.054
R45 VPW.t1 VPW.t0 1713.64
R46 VPW.t2 VPW.t3 1211.36
R47 VPW.t0 VPW.t2 1181.82
R48 VPW.t6 VPW.t1 1181.82
R49 VPW.t5 VPW.t4 1181.82
R50 VPW VPW.t5 989.774
R51 VPW.t4 VPW.t6 975
C0 a_464_68# VSS 0.65816f
C1 S a_332_68# 0.00867f
C2 B a_28_68# 0.14964f
C3 Y A 0
C4 B a_464_68# 0.00263f
C5 a_464_68# Y 0.50698f
C6 a_28_68# a_332_68# 0
C7 a_464_68# a_332_68# 0.00197f
C8 a_744_440# VDD 0.00387f
C9 a_744_440# S 0.00137f
C10 a_332_440# VDD 0.01555f
C11 a_332_440# S 0.00374f
C12 B VSS 0.01448f
C13 Y VSS 0.07862f
C14 S a_624_68# 0.01087f
C15 a_744_440# A 0.00193f
C16 a_332_68# VSS 0.00627f
C17 a_744_440# a_28_68# 0
C18 a_28_68# a_332_440# 0.03537f
C19 a_744_440# a_464_68# 0.01068f
C20 a_464_68# a_332_440# 0.00553f
C21 a_624_68# A 0
C22 a_28_68# a_624_68# 0
C23 a_464_68# a_624_68# 0.02056f
C24 B a_332_68# 0
C25 VNW VDD 0.18757f
C26 VNW S 0.18924f
C27 VSS a_624_68# 0.00594f
C28 VNW A 0.06652f
C29 VNW a_28_68# 0.12201f
C30 S VDD 0.0275f
C31 VNW a_464_68# 0.18238f
C32 a_744_440# Y 0
C33 B a_332_440# 0.00521f
C34 A VDD 0.01685f
C35 a_28_68# VDD 0.29135f
C36 S A 0.25553f
C37 a_28_68# S 0.63803f
C38 a_464_68# VDD 0.44867f
C39 VNW VSS 0.0071f
C40 a_464_68# S 0.45839f
C41 a_28_68# A 0.00654f
C42 a_464_68# A 0.28128f
C43 a_28_68# a_464_68# 0.06044f
C44 VSS VDD 0.03421f
C45 B VNW 0.08053f
C46 S VSS 0.15807f
C47 VNW Y 0.0172f
C48 VSS A 0.01212f
C49 a_28_68# VSS 0.0374f
C50 B VDD 0.01757f
C51 Y VDD 0.21938f
C52 B S 0.26671f
C53 VSS VPW 0.54415f
C54 Y VPW 0.03603f
C55 VDD VPW 0.40454f
C56 A VPW 0.27627f
C57 B VPW 0.23277f
C58 S VPW 0.96526f
C59 VNW VPW 2.43844f
C60 a_464_68# VPW 0.22952f
C61 a_28_68# VPW 0.18143f
C62 VNW.t3 VPW 0.20245f
C63 VNW.t2 VPW 0.0911f
C64 VNW.t0 VPW 0.07648f
C65 VNW.t6 VPW 0.07648f
C66 VNW.t1 VPW 0.11585f
C67 VNW.t4 VPW 0.11585f
C68 VNW.t5 VPW 0.08267f
C69 S.t0 VPW 0.15799f
C70 S.t3 VPW 0.16842f
C71 S.t1 VPW 0.12061f
C72 S.n0 VPW 0.21392f
C73 S.n1 VPW 0.4381f
C74 S.t2 VPW 0.20346f
C75 B.t1 VPW 0.12967f
C76 B.t0 VPW 0.09335f
C77 B.n0 VPW 0.16537f
C78 A.t1 VPW 0.15632f
C79 A.t0 VPW 0.11273f
C80 A.n0 VPW 0.18167f
C81 VDD.t0 VPW 0.03326f
C82 VDD.t1 VPW 0.03326f
C83 VDD.n0 VPW 0.06672f
C84 VDD.t2 VPW 0.03326f
C85 VDD.t4 VPW 0.03326f
C86 VDD.n1 VPW 0.06672f
C87 VDD.t3 VPW 0.12749f
C88 VDD.n2 VPW 0.53728f
C89 VDD.n3 VPW 0.26897f
C90 Y.t1 VPW 0.07113f
C91 Y.t0 VPW 0.0766f
C92 Y.n0 VPW 0.1748f
C93 Y.t3 VPW 0.05154f
C94 Y.t2 VPW 0.05551f
C95 Y.n1 VPW 0.10705f
C96 Y.n2 VPW 0.27581f
C97 VSS.t0 VPW 0.02155f
C98 VSS.t1 VPW 0.02155f
C99 VSS.n0 VPW 0.04324f
C100 VSS.t2 VPW 0.02155f
C101 VSS.t4 VPW 0.02155f
C102 VSS.n1 VPW 0.04324f
C103 VSS.t3 VPW 0.08469f
C104 VSS.n2 VPW 0.45884f
C105 VSS.n3 VPW 0.24047f
.ends

* NGSPICE file created from gf180mcu_as_sc_mcu7t3v3__mux2_4.ext - technology: gf180mcuD

.subckt gf180mcu_as_sc_mcu7t3v3__mux2_4 VDD VNW VPW VSS S B A Y
X0 a_744_440# S.t2 a_464_68# VNW.t8 pfet_03v3 ad=0.1932p pd=1.66u as=0.3588p ps=1.9u w=1.38u l=0.28u
X1 VDD.t1 A.t1 a_744_440# VNW.t0 pfet_03v3 ad=0.3588p pd=1.9u as=0.1932p ps=1.66u w=1.38u l=0.28u
X2 VDD.t6 a_464_68# Y.t7 VNW.t5 pfet_03v3 ad=0.828p pd=3.96u as=0.3588p ps=1.9u w=1.38u l=0.28u
X3 a_332_440# B.t1 VDD.t0 VNW.t6 pfet_03v3 ad=0.6762p pd=2.36u as=0.3588p ps=1.9u w=1.38u l=0.28u
X4 a_464_68# S.t0 a_332_68# VPW.t8 nfet_03v3 ad=0.26p pd=1.52u as=0.19p ps=1.38u w=1u l=0.28u
X5 VSS.t0 S.t1 a_28_68# VPW.t7 nfet_03v3 ad=0.26p pd=1.52u as=0.44p ps=2.88u w=1u l=0.28u
X6 Y.t0 a_464_68# VDD.t3 VNW.t2 pfet_03v3 ad=0.3726p pd=1.92u as=0.3588p ps=1.9u w=1.38u l=0.28u
X7 Y.t2 a_464_68# VSS.t3 VPW.t2 nfet_03v3 ad=0.27p pd=1.54u as=0.26p ps=1.52u w=1u l=0.28u
X8 VSS.t2 a_464_68# Y.t5 VPW.t5 nfet_03v3 ad=0.6p pd=3.2u as=0.26p ps=1.52u w=1u l=0.28u
X9 VSS.t1 A.t0 a_624_68# VPW.t0 nfet_03v3 ad=0.26p pd=1.52u as=0.44p ps=1.88u w=1u l=0.28u
X10 VDD.t4 a_464_68# Y.t1 VNW.t3 pfet_03v3 ad=0.3588p pd=1.9u as=0.3726p ps=1.92u w=1.38u l=0.28u
X11 Y.t4 a_464_68# VSS.t4 VPW.t4 nfet_03v3 ad=0.26p pd=1.52u as=0.26p ps=1.52u w=1u l=0.28u
X12 Y.t6 a_464_68# VDD.t5 VNW.t4 pfet_03v3 ad=0.3588p pd=1.9u as=0.3588p ps=1.9u w=1.38u l=0.28u
X13 VSS.t5 a_464_68# Y.t3 VPW.t3 nfet_03v3 ad=0.26p pd=1.52u as=0.27p ps=1.54u w=1u l=0.28u
X14 a_464_68# a_28_68# a_332_440# VNW.t1 pfet_03v3 ad=0.3588p pd=1.9u as=0.6762p ps=2.36u w=1.38u l=0.28u
X15 VDD.t2 S.t3 a_28_68# VNW.t7 pfet_03v3 ad=0.3588p pd=1.9u as=0.6072p ps=3.64u w=1.38u l=0.28u
X16 a_624_68# a_28_68# a_464_68# VPW.t1 nfet_03v3 ad=0.44p pd=1.88u as=0.26p ps=1.52u w=1u l=0.28u
X17 a_332_68# B.t0 VSS.t6 VPW.t6 nfet_03v3 ad=0.19p pd=1.38u as=0.26p ps=1.52u w=1u l=0.28u
R0 VSS.n4 VSS.n1 6.38659
R1 VSS.n5 VSS.n0 6.38659
R2 VSS.n3 VSS.t2 5.2398
R3 VSS.n3 VSS.n2 3.3618
R4 VSS.n2 VSS.t4 1.6385
R5 VSS.n2 VSS.t5 1.6385
R6 VSS.n1 VSS.t3 1.6385
R7 VSS.n1 VSS.t1 1.6385
R8 VSS.n0 VSS.t6 1.6385
R9 VSS.n0 VSS.t0 1.6385
R10 VSS.n5 VSS.n4 0.5135
R11 VSS.n4 VSS.n3 0.2435
R12 VSS VSS.n5 0.1685
R13 Y.n7 Y.n6 6.3005
R14 Y.n3 Y.n2 6.3005
R15 Y.n5 Y.n0 2.88005
R16 Y.n4 Y.n1 2.88005
R17 Y.n6 Y.t2 1.7645
R18 Y.n2 Y.t5 1.6385
R19 Y.n2 Y.t4 1.6385
R20 Y.n6 Y.t3 1.6385
R21 Y.n0 Y.t0 1.42079
R22 Y.n1 Y.t7 1.31934
R23 Y.n1 Y.t6 1.31934
R24 Y.n0 Y.t1 1.31934
R25 Y.n5 Y.n4 0.497457
R26 Y.n7 Y.n5 0.168227
R27 Y.n4 Y.n3 0.168227
R28 Y Y.n7 0.0468636
R29 Y.n3 Y 0.0468636
R30 VDD.n5 VDD.n0 5.28659
R31 VDD.n4 VDD.n1 5.28659
R32 VDD.n3 VDD.t6 3.57833
R33 VDD.n3 VDD.n2 2.01949
R34 VDD.n0 VDD.t0 1.31934
R35 VDD.n0 VDD.t2 1.31934
R36 VDD.n1 VDD.t3 1.31934
R37 VDD.n1 VDD.t1 1.31934
R38 VDD.n2 VDD.t5 1.31934
R39 VDD.n2 VDD.t4 1.31934
R40 VDD.n5 VDD.n4 0.5135
R41 VDD.n4 VDD.n3 0.2435
R42 VDD VDD.n5 0.1685
R43 A.n0 A.t1 27.9549
R44 A.n0 A.t0 23.0882
R45 A A.n0 8.0505
R46 B.n0 B.t1 27.332
R47 B.n0 B.t0 22.5088
R48 B B.n0 8.05423
R49 S S.t2 36.2051
R50 S.n1 S.t0 31.1981
R51 S.n0 S.t3 27.419
R52 S.n0 S.t1 22.4219
R53 S S.n0 8.05289
R54 S.n1 S 0.683326
R55 S S.n1 0.652022
R56 VNW.t6 VNW.t1 488.373
R57 VNW.t2 VNW.t3 317.829
R58 VNW.t4 VNW.t5 310.079
R59 VNW.t3 VNW.t4 310.079
R60 VNW.t0 VNW.t2 310.079
R61 VNW.t1 VNW.t8 310.079
R62 VNW.t7 VNW.t6 310.079
R63 VNW VNW.t7 259.69
R64 VNW.t8 VNW.t0 217.054
R65 VPW.t1 VPW.t0 1713.64
R66 VPW.t2 VPW.t3 1211.36
R67 VPW.t4 VPW.t5 1181.82
R68 VPW.t3 VPW.t4 1181.82
R69 VPW.t0 VPW.t2 1181.82
R70 VPW.t8 VPW.t1 1181.82
R71 VPW.t7 VPW.t6 1181.82
R72 VPW VPW.t7 989.774
R73 VPW.t6 VPW.t8 975
C0 S a_744_440# 0.00137f
C1 S a_332_68# 0.00867f
C2 VDD Y 0.59506f
C3 a_28_68# A 0.00654f
C4 VNW B 0.08053f
C5 VNW VSS 0.00787f
C6 a_332_68# B 0
C7 a_332_68# VSS 0.00627f
C8 a_624_68# A 0
C9 a_28_68# VNW 0.12201f
C10 a_28_68# a_744_440# 0
C11 a_464_68# A 0.28128f
C12 a_28_68# a_332_68# 0
C13 VDD A 0.01685f
C14 S B 0.26671f
C15 S VSS 0.15807f
C16 S a_332_440# 0.00374f
C17 VNW a_464_68# 0.35806f
C18 VNW VDD 0.24542f
C19 A Y 0
C20 S a_28_68# 0.63803f
C21 a_744_440# a_464_68# 0.01068f
C22 a_332_68# a_464_68# 0.00197f
C23 a_744_440# VDD 0.00387f
C24 B VSS 0.01448f
C25 B a_332_440# 0.00521f
C26 S a_624_68# 0.01087f
C27 VNW Y 0.03772f
C28 a_28_68# B 0.14964f
C29 a_28_68# VSS 0.0374f
C30 a_744_440# Y 0
C31 S a_464_68# 0.45839f
C32 a_28_68# a_332_440# 0.03537f
C33 S VDD 0.0275f
C34 a_624_68# VSS 0.00594f
C35 B a_464_68# 0.00263f
C36 a_464_68# VSS 0.71303f
C37 a_464_68# a_332_440# 0.00553f
C38 VDD B 0.01757f
C39 VDD VSS 0.0352f
C40 VDD a_332_440# 0.01555f
C41 a_28_68# a_624_68# 0
C42 VNW A 0.06652f
C43 a_28_68# a_464_68# 0.06044f
C44 a_744_440# A 0.00193f
C45 a_28_68# VDD 0.29135f
C46 VSS Y 0.27599f
C47 a_624_68# a_464_68# 0.02056f
C48 S A 0.25553f
C49 VDD a_464_68# 0.50666f
C50 S VNW 0.18924f
C51 a_464_68# Y 0.60897f
C52 A VSS 0.01212f
C53 VSS VPW 0.64154f
C54 Y VPW 0.05546f
C55 VDD VPW 0.47097f
C56 A VPW 0.27627f
C57 B VPW 0.23277f
C58 S VPW 0.96526f
C59 VNW VPW 2.96436f
C60 a_464_68# VPW 0.4414f
C61 a_28_68# VPW 0.18143f
C62 VNW.t5 VPW 0.22363f
C63 VNW.t4 VPW 0.09567f
C64 VNW.t3 VPW 0.09687f
C65 VNW.t2 VPW 0.09687f
C66 VNW.t0 VPW 0.08132f
C67 VNW.t8 VPW 0.08132f
C68 VNW.t1 VPW 0.12318f
C69 VNW.t6 VPW 0.12318f
C70 VNW.t7 VPW 0.0879f
C71 S.t0 VPW 0.15799f
C72 S.t3 VPW 0.16842f
C73 S.t1 VPW 0.12061f
C74 S.n0 VPW 0.21392f
C75 S.n1 VPW 0.4381f
C76 S.t2 VPW 0.20346f
C77 B.t1 VPW 0.12967f
C78 B.t0 VPW 0.09335f
C79 B.n0 VPW 0.16537f
C80 A.t1 VPW 0.15632f
C81 A.t0 VPW 0.11273f
C82 A.n0 VPW 0.18167f
C83 VDD.t0 VPW 0.0355f
C84 VDD.t2 VPW 0.0355f
C85 VDD.n0 VPW 0.0712f
C86 VDD.t3 VPW 0.0355f
C87 VDD.t1 VPW 0.0355f
C88 VDD.n1 VPW 0.0712f
C89 VDD.t5 VPW 0.0355f
C90 VDD.t4 VPW 0.0355f
C91 VDD.n2 VPW 0.07802f
C92 VDD.t6 VPW 0.1364f
C93 VDD.n3 VPW 0.51497f
C94 VDD.n4 VPW 0.31673f
C95 VDD.n5 VPW 0.28705f
C96 Y.t1 VPW 0.06195f
C97 Y.t0 VPW 0.06672f
C98 Y.n0 VPW 0.14087f
C99 Y.t7 VPW 0.06195f
C100 Y.t6 VPW 0.06195f
C101 Y.n1 VPW 0.13611f
C102 Y.t5 VPW 0.04489f
C103 Y.t4 VPW 0.04489f
C104 Y.n2 VPW 0.08979f
C105 Y.n3 VPW 0.04473f
C106 Y.n4 VPW 0.25733f
C107 Y.n5 VPW 0.25733f
C108 Y.t3 VPW 0.04489f
C109 Y.t2 VPW 0.04835f
C110 Y.n6 VPW 0.09324f
C111 Y.n7 VPW 0.04473f
C112 VSS.t6 VPW 0.02086f
C113 VSS.t0 VPW 0.02086f
C114 VSS.n0 VPW 0.04186f
C115 VSS.t3 VPW 0.02086f
C116 VSS.t1 VPW 0.02086f
C117 VSS.n1 VPW 0.04186f
C118 VSS.t4 VPW 0.02086f
C119 VSS.t5 VPW 0.02086f
C120 VSS.n2 VPW 0.04368f
C121 VSS.t2 VPW 0.08219f
C122 VSS.n3 VPW 0.38806f
C123 VSS.n4 VPW 0.25686f
C124 VSS.n5 VPW 0.2328f
.ends

* NGSPICE file created from gf180mcu_as_sc_mcu7t3v3__nand2_2.ext - technology: gf180mcuD

.subckt gf180mcu_as_sc_mcu7t3v3__nand2_2 VDD VNW VPW VSS Y B A
X0 VDD.t2 A.t2 Y.t4 VNW.t3 pfet_03v3 ad=0.3588p pd=1.9u as=0.3588p ps=1.9u w=1.38u l=0.28u
X1 VSS.t1 A.t1 a_28_68# VPW.t2 nfet_03v3 ad=0.26p pd=1.52u as=0.44p ps=2.88u w=1u l=0.28u
X2 Y.t3 B.t3 VDD.t1 VNW.t0 pfet_03v3 ad=0.3588p pd=1.9u as=0.3588p ps=1.9u w=1.38u l=0.28u
X3 a_28_68# B.t0 Y.t0 VPW.t1 nfet_03v3 ad=0.515p pd=3.03u as=0.26p ps=1.52u w=1u l=0.28u
X4 VDD.t0 B.t2 Y.t1 VNW.t1 pfet_03v3 ad=0.7176p pd=3.8u as=0.3588p ps=1.9u w=1.38u l=0.28u
X5 Y.t2 B.t1 a_28_68# VPW.t0 nfet_03v3 ad=0.26p pd=1.52u as=0.26p ps=1.52u w=1u l=0.28u
X6 Y.t5 A.t3 VDD.t3 VNW.t2 pfet_03v3 ad=0.3588p pd=1.9u as=0.6072p ps=3.64u w=1.38u l=0.28u
X7 a_28_68# A.t0 VSS.t0 VPW.t3 nfet_03v3 ad=0.26p pd=1.52u as=0.26p ps=1.52u w=1u l=0.28u
R0 VSS VSS.n0 6.55459
R1 VSS.n0 VSS.t0 1.6385
R2 VSS.n0 VSS.t1 1.6385
R3 Y.n4 Y.n0 6.44883
R4 Y.n3 Y.n1 5.82659
R5 Y.n3 Y.n2 5.2005
R6 Y.n0 Y.t0 1.6385
R7 Y.n0 Y.t2 1.6385
R8 Y.n1 Y.t4 1.31934
R9 Y.n1 Y.t5 1.31934
R10 Y.n2 Y.t1 1.31934
R11 Y.n2 Y.t3 1.31934
R12 Y.n4 Y.n3 0.500162
R13 Y Y.n4 0.0263511
R14 VDD.n1 VDD.t0 12.3927
R15 VDD.n2 VDD.t3 6.67978
R16 VDD.n1 VDD.n0 5.28659
R17 VDD.n0 VDD.t1 1.31934
R18 VDD.n0 VDD.t2 1.31934
R19 VDD.n2 VDD.n1 0.2405
R20 VDD VDD.n2 0.0485
R21 B.n0 B.t2 22.813
R22 B.n1 B.t3 22.813
R23 B.n0 B.t0 20.0755
R24 B.n1 B.t1 20.0755
R25 B.n2 B.n0 10.0042
R26 B.n2 B.n1 4.41655
R27 B B.n2 4.09717
R28 A.n0 A.t2 22.6826
R29 A.n1 A.t3 22.6826
R30 A.n0 A.t0 20.2059
R31 A.n1 A.t1 20.2059
R32 A.n2 A.n0 7.93136
R33 A.n2 A.n1 6.48939
R34 A A.n2 4.12939
R35 VNW.t0 VNW.t1 310.079
R36 VNW.t3 VNW.t0 310.079
R37 VNW.t2 VNW.t3 310.079
R38 VNW VNW.t2 259.69
R39 VPW.t0 VPW.t1 1181.82
R40 VPW.t3 VPW.t0 1181.82
R41 VPW.t2 VPW.t3 1181.82
R42 VPW VPW.t2 989.774
C0 Y A 0.06768f
C1 a_28_68# A 0.14347f
C2 B VDD 0.03228f
C3 VSS VDD 0.00645f
C4 a_28_68# Y 0.23082f
C5 A VDD 0.05336f
C6 VNW B 0.16538f
C7 VNW VSS 0.00322f
C8 Y VDD 0.35096f
C9 a_28_68# VDD 0.01414f
C10 VSS B 0.01831f
C11 VNW A 0.16961f
C12 VNW Y 0.03325f
C13 VNW a_28_68# 0.00406f
C14 A B 0.0705f
C15 VSS A 0.03089f
C16 Y B 0.27263f
C17 a_28_68# B 0.0481f
C18 Y VSS 0.00347f
C19 a_28_68# VSS 0.61565f
C20 VNW VDD 0.12007f
C21 VSS VPW 0.83377f
C22 Y VPW 0.10702f
C23 VDD VPW 0.23823f
C24 B VPW 0.30446f
C25 A VPW 0.33666f
C26 VNW VPW 1.56439f
C27 a_28_68# VPW 0.0378f
C28 VNW.t1 VPW 0.169f
C29 VNW.t0 VPW 0.08295f
C30 VNW.t3 VPW 0.08295f
C31 VNW.t2 VPW 0.07621f
C32 A.t2 VPW 0.0595f
C33 A.t0 VPW 0.04388f
C34 A.n0 VPW 0.08831f
C35 A.t3 VPW 0.0595f
C36 A.t1 VPW 0.04388f
C37 A.n1 VPW 0.09211f
C38 A.n2 VPW 0.04062f
C39 B.t2 VPW 0.07261f
C40 B.t0 VPW 0.05321f
C41 B.n0 VPW 0.11413f
C42 B.t3 VPW 0.07261f
C43 B.t1 VPW 0.05321f
C44 B.n1 VPW 0.10197f
C45 B.n2 VPW 0.04789f
C46 VDD.t3 VPW 0.06387f
C47 VDD.t1 VPW 0.02179f
C48 VDD.t2 VPW 0.02179f
C49 VDD.n0 VPW 0.0437f
C50 VDD.t0 VPW 0.07389f
C51 VDD.n1 VPW 0.23894f
C52 VDD.n2 VPW 0.10161f
C53 Y.t0 VPW 0.03634f
C54 Y.t2 VPW 0.03634f
C55 Y.n0 VPW 0.07316f
C56 Y.t4 VPW 0.05015f
C57 Y.t5 VPW 0.05015f
C58 Y.n1 VPW 0.10551f
C59 Y.t1 VPW 0.05015f
C60 Y.t3 VPW 0.05015f
C61 Y.n2 VPW 0.1003f
C62 Y.n3 VPW 0.1907f
C63 Y.n4 VPW 0.207f
C64 VSS.t0 VPW 0.02976f
C65 VSS.t1 VPW 0.02976f
C66 VSS.n0 VPW 0.07207f
.ends

* NGSPICE file created from gf180mcu_as_sc_mcu7t3v3__nand2_4.ext - technology: gf180mcuD

.subckt gf180mcu_as_sc_mcu7t3v3__nand2_4 VDD VNW VPW VSS Y A B
X0 a_28_68# B.t2 Y.t1 VPW.t1 nfet_03v3 ad=0.26p pd=1.52u as=0.26p ps=1.52u w=1u l=0.28u
X1 VDD.t4 A.t6 Y.t7 VNW.t5 pfet_03v3 ad=0.3588p pd=1.9u as=0.3588p ps=1.9u w=1.38u l=0.28u
X2 Y.t10 B.t7 VDD.t7 VNW.t0 pfet_03v3 ad=0.3588p pd=1.9u as=0.3588p ps=1.9u w=1.38u l=0.28u
X3 VSS.t3 A.t3 a_28_68# VPW.t4 nfet_03v3 ad=0.26p pd=1.52u as=0.44p ps=2.88u w=1u l=0.28u
X4 VDD.t0 B.t4 Y.t3 VNW.t3 pfet_03v3 ad=0.9384p pd=4.12u as=0.3588p ps=1.9u w=1.38u l=0.28u
X5 Y.t2 B.t3 a_28_68# VPW.t0 nfet_03v3 ad=0.26p pd=1.52u as=0.26p ps=1.52u w=1u l=0.28u
X6 Y.t6 A.t5 VDD.t3 VNW.t6 pfet_03v3 ad=0.3588p pd=1.9u as=0.3588p ps=1.9u w=1.38u l=0.28u
X7 VDD.t6 B.t6 Y.t9 VNW.t1 pfet_03v3 ad=0.3588p pd=1.9u as=0.3588p ps=1.9u w=1.38u l=0.28u
X8 a_28_68# A.t0 VSS.t1 VPW.t7 nfet_03v3 ad=0.26p pd=1.52u as=0.26p ps=1.52u w=1u l=0.28u
X9 a_28_68# B.t0 Y.t0 VPW.t3 nfet_03v3 ad=0.68p pd=3.36u as=0.26p ps=1.52u w=1u l=0.28u
X10 VDD.t2 A.t4 Y.t5 VNW.t7 pfet_03v3 ad=0.3588p pd=1.9u as=0.3588p ps=1.9u w=1.38u l=0.28u
X11 VSS.t0 A.t1 a_28_68# VPW.t6 nfet_03v3 ad=0.26p pd=1.52u as=0.26p ps=1.52u w=1u l=0.28u
X12 Y.t4 B.t5 VDD.t1 VNW.t2 pfet_03v3 ad=0.3588p pd=1.9u as=0.3588p ps=1.9u w=1.38u l=0.28u
X13 Y.t11 B.t1 a_28_68# VPW.t2 nfet_03v3 ad=0.26p pd=1.52u as=0.26p ps=1.52u w=1u l=0.28u
X14 Y.t8 A.t7 VDD.t5 VNW.t4 pfet_03v3 ad=0.3588p pd=1.9u as=0.6072p ps=3.64u w=1.38u l=0.28u
X15 a_28_68# A.t2 VSS.t2 VPW.t5 nfet_03v3 ad=0.26p pd=1.52u as=0.26p ps=1.52u w=1u l=0.28u
R0 VSS.n2 VSS.n1 6.62659
R1 VSS.n2 VSS.n0 6.38659
R2 VSS.n1 VSS.t1 1.6385
R3 VSS.n1 VSS.t0 1.6385
R4 VSS.n0 VSS.t2 1.6385
R5 VSS.n0 VSS.t3 1.6385
R6 VSS VSS.n2 0.1685
R7 Y.n9 Y.n0 6.88159
R8 Y.n9 Y.n8 6.3005
R9 Y.n4 Y.n2 5.82659
R10 Y.n6 Y.n5 5.2005
R11 Y.n4 Y.n3 5.2005
R12 Y.n7 Y.n1 2.63572
R13 Y.n8 Y.t0 1.6385
R14 Y.n8 Y.t11 1.6385
R15 Y.n0 Y.t1 1.6385
R16 Y.n0 Y.t2 1.6385
R17 Y.n1 Y.t3 1.31934
R18 Y.n1 Y.t4 1.31934
R19 Y.n2 Y.t7 1.31934
R20 Y.n2 Y.t8 1.31934
R21 Y.n3 Y.t5 1.31934
R22 Y.n3 Y.t6 1.31934
R23 Y.n5 Y.t9 1.31934
R24 Y.n5 Y.t10 1.31934
R25 Y.n7 Y.n6 0.626587
R26 Y.n6 Y.n4 0.626587
R27 Y.n9 Y.n7 0.36838
R28 Y Y.n9 0.02925
R29 VDD.n5 VDD.n0 5.28659
R30 VDD.n4 VDD.n1 5.28659
R31 VDD.n3 VDD.n2 5.28659
R32 VDD.n3 VDD.t0 3.57833
R33 VDD.n6 VDD.t5 3.33441
R34 VDD.n0 VDD.t3 1.31934
R35 VDD.n0 VDD.t4 1.31934
R36 VDD.n1 VDD.t7 1.31934
R37 VDD.n1 VDD.t2 1.31934
R38 VDD.n2 VDD.t1 1.31934
R39 VDD.n2 VDD.t6 1.31934
R40 VDD.n4 VDD.n3 0.2405
R41 VDD.n5 VDD.n4 0.2405
R42 VDD.n6 VDD.n5 0.2405
R43 VDD VDD.n6 0.0485
R44 B.n0 B.t4 21.9005
R45 B.n1 B.t5 21.9005
R46 B.n2 B.t6 21.9005
R47 B.n3 B.t7 21.9005
R48 B.n0 B.t0 19.6844
R49 B.n1 B.t1 19.6844
R50 B.n2 B.t2 19.6844
R51 B.n3 B.t3 19.6844
R52 B.n1 B.n0 12.8357
R53 B.n2 B.n1 12.8357
R54 B.n4 B.n3 12.7554
R55 B B.n4 2.1627
R56 B.n4 B.n2 0.0807198
R57 A.n0 A.t4 21.7701
R58 A.n1 A.t5 21.7701
R59 A.n3 A.t6 21.7701
R60 A.n2 A.t7 21.7701
R61 A.n0 A.t0 19.8148
R62 A.n1 A.t1 19.8148
R63 A.n3 A.t2 19.8148
R64 A.n2 A.t3 19.8148
R65 A.n1 A.n0 12.8357
R66 A.n3 A.n2 12.8357
R67 A.n4 A.n1 6.81918
R68 A.n4 A.n3 6.01698
R69 A A.n4 1.86061
R70 VNW.t2 VNW.t3 310.079
R71 VNW.t1 VNW.t2 310.079
R72 VNW.t0 VNW.t1 310.079
R73 VNW.t7 VNW.t0 310.079
R74 VNW.t6 VNW.t7 310.079
R75 VNW.t5 VNW.t6 310.079
R76 VNW.t4 VNW.t5 310.079
R77 VNW VNW.t4 253.876
R78 VPW.t2 VPW.t3 1181.82
R79 VPW.t1 VPW.t2 1181.82
R80 VPW.t0 VPW.t1 1181.82
R81 VPW.t7 VPW.t0 1181.82
R82 VPW.t6 VPW.t7 1181.82
R83 VPW.t5 VPW.t6 1181.82
R84 VPW.t4 VPW.t5 1181.82
R85 VPW VPW.t4 989.774
C0 a_28_68# A 0.4133f
C1 B VNW 0.34085f
C2 VDD VNW 0.24714f
C3 VSS A 0.06606f
C4 Y B 0.59082f
C5 Y VDD 0.57053f
C6 a_28_68# B 0.06201f
C7 VDD a_28_68# 0.03631f
C8 VSS B 0.03653f
C9 Y VNW 0.06425f
C10 VSS VDD 0.00953f
C11 a_28_68# VNW 0.00641f
C12 VSS VNW 0.00376f
C13 Y a_28_68# 0.49033f
C14 VSS Y 0.00466f
C15 VSS a_28_68# 1.08906f
C16 B A 0.05893f
C17 VDD A 0.09349f
C18 A VNW 0.34322f
C19 VDD B 0.08557f
C20 Y A 0.3063f
C21 VSS VPW 0.54751f
C22 Y VPW 0.05652f
C23 VDD VPW 0.41351f
C24 B VPW 0.60405f
C25 A VPW 0.70853f
C26 VNW VPW 2.6199f
C27 a_28_68# VPW 0.04409f
C28 VNW.t3 VPW 0.22299f
C29 VNW.t2 VPW 0.09883f
C30 VNW.t1 VPW 0.09883f
C31 VNW.t0 VPW 0.09883f
C32 VNW.t7 VPW 0.09883f
C33 VNW.t6 VPW 0.09883f
C34 VNW.t5 VPW 0.09883f
C35 VNW.t4 VPW 0.08988f
C36 A.t5 VPW 0.06352f
C37 A.t1 VPW 0.04724f
C38 A.t4 VPW 0.06352f
C39 A.t0 VPW 0.04724f
C40 A.n0 VPW 0.11988f
C41 A.n1 VPW 0.12831f
C42 A.t6 VPW 0.06352f
C43 A.t2 VPW 0.04724f
C44 A.t7 VPW 0.06352f
C45 A.t3 VPW 0.04724f
C46 A.n2 VPW 0.11988f
C47 A.n3 VPW 0.1254f
C48 A.n4 VPW 0.07754f
C49 B.t6 VPW 0.06372f
C50 B.t2 VPW 0.04707f
C51 B.t5 VPW 0.06372f
C52 B.t1 VPW 0.04707f
C53 B.t4 VPW 0.06372f
C54 B.t0 VPW 0.04707f
C55 B.n0 VPW 0.11992f
C56 B.n1 VPW 0.15017f
C57 B.n2 VPW 0.10392f
C58 B.t7 VPW 0.06372f
C59 B.t3 VPW 0.04707f
C60 B.n3 VPW 0.11963f
C61 B.n4 VPW 0.05731f
C62 VDD.t5 VPW 0.05307f
C63 VDD.t3 VPW 0.02079f
C64 VDD.t4 VPW 0.02079f
C65 VDD.n0 VPW 0.04171f
C66 VDD.t7 VPW 0.02079f
C67 VDD.t2 VPW 0.02079f
C68 VDD.n1 VPW 0.04171f
C69 VDD.t1 VPW 0.02079f
C70 VDD.t6 VPW 0.02079f
C71 VDD.n2 VPW 0.04171f
C72 VDD.t0 VPW 0.08772f
C73 VDD.n3 VPW 0.27674f
C74 VDD.n4 VPW 0.12154f
C75 VDD.n5 VPW 0.12154f
C76 VDD.n6 VPW 0.12098f
C77 Y.t1 VPW 0.04277f
C78 Y.t2 VPW 0.04277f
C79 Y.n0 VPW 0.09178f
C80 Y.t3 VPW 0.05902f
C81 Y.t4 VPW 0.05902f
C82 Y.n1 VPW 0.11868f
C83 Y.t7 VPW 0.05902f
C84 Y.t8 VPW 0.05902f
C85 Y.n2 VPW 0.12698f
C86 Y.t5 VPW 0.05902f
C87 Y.t6 VPW 0.05902f
C88 Y.n3 VPW 0.11804f
C89 Y.n4 VPW 0.19535f
C90 Y.t9 VPW 0.05902f
C91 Y.t10 VPW 0.05902f
C92 Y.n5 VPW 0.11804f
C93 Y.n6 VPW 0.12106f
C94 Y.n7 VPW 0.18629f
C95 Y.t0 VPW 0.04277f
C96 Y.t11 VPW 0.04277f
C97 Y.n8 VPW 0.08553f
C98 Y.n9 VPW 0.21514f
C99 VSS.t2 VPW 0.02814f
C100 VSS.t3 VPW 0.02814f
C101 VSS.n0 VPW 0.05647f
C102 VSS.t1 VPW 0.02814f
C103 VSS.t0 VPW 0.02814f
C104 VSS.n1 VPW 0.08239f
C105 VSS.n2 VPW 0.88543f
.ends

* NGSPICE file created from gf180mcu_as_sc_mcu7t3v3__nand2b_2.ext - technology: gf180mcuD

.subckt gf180mcu_as_sc_mcu7t3v3__nand2b_2 VDD VNW VPW VSS Y B A
X0 a_364_68# a_220_68# VSS.t2 VPW.t4 nfet_03v3 ad=0.26p pd=1.52u as=0.26p ps=1.52u w=1u l=0.28u
X1 a_220_68# A.t0 VSS.t0 VPW.t2 nfet_03v3 ad=0.44p pd=2.88u as=0.46p ps=2.92u w=1u l=0.28u
X2 VSS.t1 a_220_68# a_364_68# VPW.t3 nfet_03v3 ad=0.26p pd=1.52u as=0.44p ps=2.88u w=1u l=0.28u
X3 a_220_68# A.t1 VDD.t2 VNW.t2 pfet_03v3 ad=0.6072p pd=3.64u as=0.6348p ps=3.68u w=1.38u l=0.28u
X4 Y.t5 a_220_68# VDD.t3 VNW.t3 pfet_03v3 ad=0.3588p pd=1.9u as=0.6072p ps=3.64u w=1.38u l=0.28u
X5 VDD.t0 B.t2 Y.t0 VNW.t1 pfet_03v3 ad=0.7176p pd=3.8u as=0.3588p ps=1.9u w=1.38u l=0.28u
X6 a_364_68# B.t0 Y.t1 VPW.t1 nfet_03v3 ad=0.515p pd=3.03u as=0.26p ps=1.52u w=1u l=0.28u
X7 VDD.t4 a_220_68# Y.t4 VNW.t4 pfet_03v3 ad=0.3588p pd=1.9u as=0.3588p ps=1.9u w=1.38u l=0.28u
X8 Y.t3 B.t1 a_364_68# VPW.t0 nfet_03v3 ad=0.26p pd=1.52u as=0.26p ps=1.52u w=1u l=0.28u
X9 Y.t2 B.t3 VDD.t1 VNW.t0 pfet_03v3 ad=0.3588p pd=1.9u as=0.3588p ps=1.9u w=1.38u l=0.28u
R0 VSS.n1 VSS.n0 6.72259
R1 VSS.n1 VSS.t0 4.9998
R2 VSS.n0 VSS.t2 1.6385
R3 VSS.n0 VSS.t1 1.6385
R4 VSS VSS.n1 0.0845
R5 Y.n4 Y.n0 6.44883
R6 Y.n3 Y.n1 5.82659
R7 Y.n3 Y.n2 5.2005
R8 Y.n0 Y.t1 1.6385
R9 Y.n0 Y.t3 1.6385
R10 Y.n1 Y.t4 1.31934
R11 Y.n1 Y.t5 1.31934
R12 Y.n2 Y.t0 1.31934
R13 Y.n2 Y.t2 1.31934
R14 Y.n4 Y.n3 0.500162
R15 Y Y.n4 0.0263511
R16 VDD.n1 VDD.t0 12.3927
R17 VDD.n1 VDD.n0 5.28659
R18 VDD.n2 VDD.t3 4.18151
R19 VDD.n3 VDD.t2 4.17565
R20 VDD.n0 VDD.t1 1.31934
R21 VDD.n0 VDD.t4 1.31934
R22 VDD.n2 VDD.n1 0.2405
R23 VDD.n3 VDD.n2 0.2165
R24 VDD VDD.n3 0.0845
R25 B.n0 B.t2 22.813
R26 B.n1 B.t3 22.813
R27 B.n0 B.t0 20.0755
R28 B.n1 B.t1 20.0755
R29 B.n2 B.n0 10.0042
R30 B.n2 B.n1 4.41655
R31 B B.n2 4.09717
R32 A.n0 A.t1 27.5635
R33 A.n0 A.t0 22.6099
R34 A A.n0 8.13936
R35 VNW.t2 VNW.t3 558.14
R36 VNW VNW.t2 352.714
R37 VNW.t0 VNW.t1 310.079
R38 VNW.t4 VNW.t0 310.079
R39 VNW.t3 VNW.t4 310.079
R40 VPW.t2 VPW.t3 2127.27
R41 VPW VPW.t2 1344.32
R42 VPW.t0 VPW.t1 1181.82
R43 VPW.t4 VPW.t0 1181.82
R44 VPW.t3 VPW.t4 1181.82
C0 a_364_68# A 0
C1 a_364_68# VNW 0.00492f
C2 VSS B 0.01831f
C3 a_220_68# B 0.05009f
C4 Y VNW 0.03279f
C5 VDD B 0.03329f
C6 Y a_364_68# 0.25153f
C7 VSS A 0.09571f
C8 a_220_68# A 0.11041f
C9 VSS VNW 0.00513f
C10 a_220_68# VNW 0.20953f
C11 VDD A 0.06966f
C12 VDD VNW 0.20109f
C13 a_364_68# VSS 0.62643f
C14 a_220_68# a_364_68# 0.11623f
C15 Y VSS 0.00412f
C16 Y a_220_68# 0.03945f
C17 VDD a_364_68# 0.00786f
C18 VDD Y 0.36625f
C19 a_220_68# VSS 0.10218f
C20 VDD VSS 0.01037f
C21 VDD a_220_68# 0.3576f
C22 VNW B 0.16651f
C23 a_364_68# B 0.0481f
C24 VNW A 0.09499f
C25 Y B 0.27263f
C26 VSS VPW 0.45832f
C27 Y VPW 0.09237f
C28 VDD VPW 0.32688f
C29 B VPW 0.30162f
C30 A VPW 0.21756f
C31 VNW VPW 2.1035f
C32 a_364_68# VPW 0.02352f
C33 a_220_68# VPW 0.23354f
C34 VNW.t1 VPW 0.1804f
C35 VNW.t0 VPW 0.08854f
C36 VNW.t4 VPW 0.08854f
C37 VNW.t3 VPW 0.12396f
C38 VNW.t2 VPW 0.13004f
C39 A.t1 VPW 0.09682f
C40 A.t0 VPW 0.06962f
C41 A.n0 VPW 0.12208f
C42 B.t2 VPW 0.07043f
C43 B.t0 VPW 0.05161f
C44 B.n0 VPW 0.11069f
C45 B.t3 VPW 0.07043f
C46 B.t1 VPW 0.05161f
C47 B.n1 VPW 0.09891f
C48 B.n2 VPW 0.04645f
C49 VDD.t2 VPW 0.0776f
C50 VDD.t3 VPW 0.07475f
C51 VDD.t1 VPW 0.02761f
C52 VDD.t4 VPW 0.02761f
C53 VDD.n0 VPW 0.05539f
C54 VDD.t0 VPW 0.09365f
C55 VDD.n1 VPW 0.30286f
C56 VDD.n2 VPW 0.20371f
C57 VDD.n3 VPW 0.15708f
C58 Y.t1 VPW 0.03664f
C59 Y.t3 VPW 0.03664f
C60 Y.n0 VPW 0.07377f
C61 Y.t4 VPW 0.05057f
C62 Y.t5 VPW 0.05057f
C63 Y.n1 VPW 0.10639f
C64 Y.t0 VPW 0.05057f
C65 Y.t2 VPW 0.05057f
C66 Y.n2 VPW 0.10113f
C67 Y.n3 VPW 0.19228f
C68 Y.n4 VPW 0.20871f
C69 VSS.t0 VPW 0.06633f
C70 VSS.t2 VPW 0.02398f
C71 VSS.t1 VPW 0.02398f
C72 VSS.n0 VPW 0.07062f
C73 VSS.n1 VPW 0.64635f
.ends

* NGSPICE file created from gf180mcu_as_sc_mcu7t3v3__nand2b_4.ext - technology: gf180mcuD

.subckt gf180mcu_as_sc_mcu7t3v3__nand2b_4 VDD VNW VPW VSS Y A B
X0 VDD.t8 B.t6 Y.t9 VNW.t1 pfet_03v3 ad=0.3588p pd=1.9u as=0.3588p ps=1.9u w=1.38u l=0.28u
X1 a_364_68# a_220_68# VSS.t2 VPW.t5 nfet_03v3 ad=0.26p pd=1.52u as=0.26p ps=1.52u w=1u l=0.28u
X2 a_364_68# B.t2 Y.t11 VPW.t1 nfet_03v3 ad=0.26p pd=1.52u as=0.26p ps=1.52u w=1u l=0.28u
X3 a_220_68# A.t0 VSS.t0 VPW.t8 nfet_03v3 ad=0.44p pd=2.88u as=0.44p ps=2.88u w=1u l=0.28u
X4 VSS.t1 a_220_68# a_364_68# VPW.t4 nfet_03v3 ad=0.26p pd=1.52u as=0.44p ps=2.88u w=1u l=0.28u
X5 a_220_68# A.t1 VDD.t2 VNW.t8 pfet_03v3 ad=0.6072p pd=3.64u as=0.6072p ps=3.64u w=1.38u l=0.28u
X6 Y.t5 a_220_68# VDD.t3 VNW.t4 pfet_03v3 ad=0.3588p pd=1.9u as=0.6072p ps=3.64u w=1.38u l=0.28u
X7 VDD.t6 a_220_68# Y.t4 VNW.t7 pfet_03v3 ad=0.3588p pd=1.9u as=0.3588p ps=1.9u w=1.38u l=0.28u
X8 Y.t10 B.t3 a_364_68# VPW.t0 nfet_03v3 ad=0.26p pd=1.52u as=0.26p ps=1.52u w=1u l=0.28u
X9 Y.t1 B.t5 VDD.t1 VNW.t2 pfet_03v3 ad=0.3588p pd=1.9u as=0.3588p ps=1.9u w=1.38u l=0.28u
X10 Y.t6 B.t7 VDD.t7 VNW.t0 pfet_03v3 ad=0.3588p pd=1.9u as=0.3588p ps=1.9u w=1.38u l=0.28u
X11 VDD.t0 B.t4 Y.t0 VNW.t3 pfet_03v3 ad=0.9384p pd=4.12u as=0.3588p ps=1.9u w=1.38u l=0.28u
X12 a_364_68# a_220_68# VSS.t4 VPW.t7 nfet_03v3 ad=0.26p pd=1.52u as=0.26p ps=1.52u w=1u l=0.28u
X13 a_364_68# B.t0 Y.t8 VPW.t3 nfet_03v3 ad=0.68p pd=3.36u as=0.26p ps=1.52u w=1u l=0.28u
X14 VDD.t4 a_220_68# Y.t2 VNW.t5 pfet_03v3 ad=0.3588p pd=1.9u as=0.3588p ps=1.9u w=1.38u l=0.28u
X15 VSS.t3 a_220_68# a_364_68# VPW.t6 nfet_03v3 ad=0.26p pd=1.52u as=0.26p ps=1.52u w=1u l=0.28u
X16 Y.t7 B.t1 a_364_68# VPW.t2 nfet_03v3 ad=0.26p pd=1.52u as=0.26p ps=1.52u w=1u l=0.28u
X17 Y.t3 a_220_68# VDD.t5 VNW.t6 pfet_03v3 ad=0.3588p pd=1.9u as=0.3588p ps=1.9u w=1.38u l=0.28u
R0 VSS.n2 VSS.n1 6.62659
R1 VSS.n2 VSS.n0 6.38659
R2 VSS.n3 VSS.t0 4.9998
R3 VSS.n1 VSS.t4 1.6385
R4 VSS.n1 VSS.t3 1.6385
R5 VSS.n0 VSS.t2 1.6385
R6 VSS.n0 VSS.t1 1.6385
R7 VSS.n3 VSS.n2 0.3365
R8 VSS VSS.n3 0.0845
R9 Y.n9 Y.n0 6.88159
R10 Y.n9 Y.n8 6.3005
R11 Y.n4 Y.n2 5.82659
R12 Y.n6 Y.n5 5.2005
R13 Y.n4 Y.n3 5.2005
R14 Y.n7 Y.n1 2.63572
R15 Y.n8 Y.t8 1.6385
R16 Y.n8 Y.t7 1.6385
R17 Y.n0 Y.t11 1.6385
R18 Y.n0 Y.t10 1.6385
R19 Y.n1 Y.t0 1.31934
R20 Y.n1 Y.t1 1.31934
R21 Y.n2 Y.t2 1.31934
R22 Y.n2 Y.t5 1.31934
R23 Y.n3 Y.t4 1.31934
R24 Y.n3 Y.t3 1.31934
R25 Y.n5 Y.t9 1.31934
R26 Y.n5 Y.t6 1.31934
R27 Y.n7 Y.n6 0.626587
R28 Y.n6 Y.n4 0.626587
R29 Y.n9 Y.n7 0.36838
R30 Y Y.n9 0.02925
R31 VDD.n5 VDD.n0 5.28659
R32 VDD.n4 VDD.n1 5.28659
R33 VDD.n3 VDD.n2 5.28659
R34 VDD.n3 VDD.t0 3.57833
R35 VDD.n7 VDD.t2 3.33833
R36 VDD.n6 VDD.t3 3.33441
R37 VDD.n0 VDD.t5 1.31934
R38 VDD.n0 VDD.t4 1.31934
R39 VDD.n1 VDD.t7 1.31934
R40 VDD.n1 VDD.t6 1.31934
R41 VDD.n2 VDD.t1 1.31934
R42 VDD.n2 VDD.t8 1.31934
R43 VDD.n4 VDD.n3 0.2405
R44 VDD.n5 VDD.n4 0.2405
R45 VDD.n6 VDD.n5 0.2405
R46 VDD.n7 VDD.n6 0.2165
R47 VDD VDD.n7 0.0845
R48 B.n0 B.t4 21.9005
R49 B.n1 B.t5 21.9005
R50 B.n2 B.t6 21.9005
R51 B.n3 B.t7 21.9005
R52 B.n0 B.t0 19.6844
R53 B.n1 B.t1 19.6844
R54 B.n2 B.t2 19.6844
R55 B.n3 B.t3 19.6844
R56 B.n1 B.n0 12.8357
R57 B.n2 B.n1 12.8357
R58 B.n4 B.n3 12.7554
R59 B B.n4 2.1627
R60 B.n4 B.n2 0.0807198
R61 A.n0 A.t1 27.6245
R62 A.n0 A.t0 22.2462
R63 A A.n0 8.11604
R64 VNW.t8 VNW.t4 558.14
R65 VNW VNW.t8 346.899
R66 VNW.t2 VNW.t3 310.079
R67 VNW.t1 VNW.t2 310.079
R68 VNW.t0 VNW.t1 310.079
R69 VNW.t7 VNW.t0 310.079
R70 VNW.t6 VNW.t7 310.079
R71 VNW.t5 VNW.t6 310.079
R72 VNW.t4 VNW.t5 310.079
R73 VPW.t8 VPW.t4 2127.27
R74 VPW VPW.t8 1344.32
R75 VPW.t2 VPW.t3 1181.82
R76 VPW.t1 VPW.t2 1181.82
R77 VPW.t0 VPW.t1 1181.82
R78 VPW.t7 VPW.t0 1181.82
R79 VPW.t6 VPW.t7 1181.82
R80 VPW.t5 VPW.t6 1181.82
R81 VPW.t4 VPW.t5 1181.82
C0 a_220_68# VDD 0.43069f
C1 VNW B 0.34503f
C2 a_220_68# a_364_68# 0.21579f
C3 a_220_68# Y 0.07662f
C4 a_364_68# VDD 0.02253f
C5 B VSS 0.03653f
C6 VDD Y 0.57053f
C7 a_364_68# Y 0.57214f
C8 a_220_68# B 0.0442f
C9 VDD B 0.08557f
C10 VNW A 0.09504f
C11 VNW VSS 0.00624f
C12 a_364_68# B 0.06201f
C13 B Y 0.59082f
C14 A VSS 0.09373f
C15 VNW a_220_68# 0.37861f
C16 VNW VDD 0.31703f
C17 a_220_68# A 0.11674f
C18 a_220_68# VSS 0.13789f
C19 VNW a_364_68# 0.01059f
C20 VNW Y 0.06864f
C21 VDD A 0.09521f
C22 VDD VSS 0.01398f
C23 a_364_68# A 0
C24 a_364_68# VSS 1.09579f
C25 VSS Y 0.00574f
C26 VSS VPW 0.64652f
C27 Y VPW 0.05725f
C28 VDD VPW 0.48656f
C29 B VPW 0.60245f
C30 A VPW 0.22294f
C31 VNW VPW 3.15748f
C32 a_364_68# VPW 0.02792f
C33 a_220_68# VPW 0.43791f
C34 VNW.t3 VPW 0.2226f
C35 VNW.t2 VPW 0.09949f
C36 VNW.t1 VPW 0.09949f
C37 VNW.t0 VPW 0.09949f
C38 VNW.t7 VPW 0.09949f
C39 VNW.t6 VPW 0.09949f
C40 VNW.t5 VPW 0.09949f
C41 VNW.t4 VPW 0.13928f
C42 VNW.t8 VPW 0.14519f
C43 A.t1 VPW 0.10464f
C44 A.t0 VPW 0.07439f
C45 A.n0 VPW 0.13442f
C46 B.t6 VPW 0.06315f
C47 B.t2 VPW 0.04665f
C48 B.t5 VPW 0.06315f
C49 B.t1 VPW 0.04665f
C50 B.t4 VPW 0.06315f
C51 B.t0 VPW 0.04665f
C52 B.n0 VPW 0.11884f
C53 B.n1 VPW 0.14882f
C54 B.n2 VPW 0.10299f
C55 B.t7 VPW 0.06315f
C56 B.t3 VPW 0.04665f
C57 B.n3 VPW 0.11855f
C58 B.n4 VPW 0.05679f
C59 VDD.t2 VPW 0.06446f
C60 VDD.t3 VPW 0.06426f
C61 VDD.t5 VPW 0.02518f
C62 VDD.t4 VPW 0.02518f
C63 VDD.n0 VPW 0.0505f
C64 VDD.t7 VPW 0.02518f
C65 VDD.t6 VPW 0.02518f
C66 VDD.n1 VPW 0.0505f
C67 VDD.t1 VPW 0.02518f
C68 VDD.t8 VPW 0.02518f
C69 VDD.n2 VPW 0.0505f
C70 VDD.t0 VPW 0.10621f
C71 VDD.n3 VPW 0.33508f
C72 VDD.n4 VPW 0.14716f
C73 VDD.n5 VPW 0.14716f
C74 VDD.n6 VPW 0.19364f
C75 VDD.n7 VPW 0.15143f
C76 Y.t11 VPW 0.03976f
C77 Y.t10 VPW 0.03976f
C78 Y.n0 VPW 0.08533f
C79 Y.t0 VPW 0.05487f
C80 Y.t1 VPW 0.05487f
C81 Y.n1 VPW 0.11034f
C82 Y.t2 VPW 0.05487f
C83 Y.t5 VPW 0.05487f
C84 Y.n2 VPW 0.11806f
C85 Y.t4 VPW 0.05487f
C86 Y.t3 VPW 0.05487f
C87 Y.n3 VPW 0.10974f
C88 Y.n4 VPW 0.18162f
C89 Y.t9 VPW 0.05487f
C90 Y.t6 VPW 0.05487f
C91 Y.n5 VPW 0.10974f
C92 Y.n6 VPW 0.11256f
C93 Y.n7 VPW 0.1732f
C94 Y.t8 VPW 0.03976f
C95 Y.t7 VPW 0.03976f
C96 Y.n8 VPW 0.07952f
C97 Y.n9 VPW 0.20003f
C98 VSS.t0 VPW 0.06609f
C99 VSS.t2 VPW 0.02483f
C100 VSS.t1 VPW 0.02483f
C101 VSS.n0 VPW 0.04983f
C102 VSS.t4 VPW 0.02483f
C103 VSS.t3 VPW 0.02483f
C104 VSS.n1 VPW 0.07269f
C105 VSS.n2 VPW 0.84537f
C106 VSS.n3 VPW 0.22452f
.ends

* NGSPICE file created from gf180mcu_as_sc_mcu7t3v3__nand3_2.ext - technology: gf180mcuD

.subckt gf180mcu_as_sc_mcu7t3v3__nand3_2 VDD VNW VPW VSS A B C Y
X0 VDD.t1 A.t2 Y.t1 VNW.t5 pfet_03v3 ad=0.3588p pd=1.9u as=0.3588p ps=1.9u w=1.38u l=0.28u
X1 VSS.t1 A.t1 a_28_68# VPW.t4 nfet_03v3 ad=0.26p pd=1.52u as=0.44p ps=2.88u w=1u l=0.28u
X2 VDD.t3 C.t2 Y.t4 VNW.t1 pfet_03v3 ad=0.621p pd=3.66u as=0.3588p ps=1.9u w=1.38u l=0.28u
X3 a_492_68# C.t0 Y.t3 VPW.t1 nfet_03v3 ad=0.45p pd=2.9u as=0.26p ps=1.52u w=1u l=0.28u
X4 Y.t7 B.t3 VDD.t5 VNW.t2 pfet_03v3 ad=0.3588p pd=1.9u as=0.3588p ps=1.9u w=1.38u l=0.28u
X5 a_28_68# B.t0 a_492_68# VPW.t3 nfet_03v3 ad=0.44p pd=2.88u as=0.26p ps=1.52u w=1u l=0.28u
X6 VDD.t4 B.t2 Y.t6 VNW.t3 pfet_03v3 ad=0.8004p pd=2.54u as=0.3588p ps=1.9u w=1.38u l=0.28u
X7 Y.t0 C.t3 VDD.t0 VNW.t0 pfet_03v3 ad=0.3588p pd=1.9u as=0.8004p ps=2.54u w=1.38u l=0.28u
X8 Y.t5 C.t1 a_492_68# VPW.t0 nfet_03v3 ad=0.26p pd=1.52u as=0.44p ps=2.88u w=1u l=0.28u
X9 a_492_68# B.t1 a_28_68# VPW.t2 nfet_03v3 ad=0.26p pd=1.52u as=0.26p ps=1.52u w=1u l=0.28u
X10 Y.t2 A.t3 VDD.t2 VNW.t4 pfet_03v3 ad=0.3588p pd=1.9u as=0.6072p ps=3.64u w=1.38u l=0.28u
X11 a_28_68# A.t0 VSS.t0 VPW.t5 nfet_03v3 ad=0.26p pd=1.52u as=0.26p ps=1.52u w=1u l=0.28u
R0 VSS VSS.n0 6.55459
R1 VSS.n0 VSS.t0 1.6385
R2 VSS.n0 VSS.t1 1.6385
R3 Y.n6 Y.n5 6.3005
R4 Y.n2 Y.n0 3.3655
R5 Y.n4 Y.n3 2.61615
R6 Y.n2 Y.n1 2.6005
R7 Y.n5 Y.t3 1.6385
R8 Y.n5 Y.t5 1.6385
R9 Y.n3 Y.t4 1.31934
R10 Y.n3 Y.t0 1.31934
R11 Y.n1 Y.t6 1.31934
R12 Y.n1 Y.t7 1.31934
R13 Y.n0 Y.t1 1.31934
R14 Y.n0 Y.t2 1.31934
R15 Y.n4 Y.n2 0.832022
R16 Y Y.n7 0.737643
R17 Y.n7 Y.n4 0.342891
R18 Y.n7 Y.n6 0.292022
R19 Y.n6 Y 0.0455
R20 VDD.n5 VDD.n3 5.28659
R21 VDD.n4 VDD.t2 4.18738
R22 VDD.n0 VDD.t3 3.56108
R23 VDD.n1 VDD.t0 2.94253
R24 VDD.n1 VDD.t4 2.94253
R25 VDD.n2 VDD.n1 2.6005
R26 VDD.n3 VDD.t5 1.31934
R27 VDD.n3 VDD.t1 1.31934
R28 VDD.n0 VDD 0.64175
R29 VDD VDD.n6 0.310045
R30 VDD.n5 VDD.n4 0.2405
R31 VDD.n6 VDD.n5 0.22325
R32 VDD.n4 VDD 0.0485
R33 VDD.n2 VDD.n0 0.0400455
R34 VDD.n6 VDD.n2 0.0400455
R35 C.n0 C.t2 29.0701
R36 C.n1 C.t3 26.7237
R37 C.n0 C.t0 24.3773
R38 C.n1 C.t1 22.091
R39 C.n1 C.n0 16.5048
R40 C C.n1 8.04325
R41 B.n0 B.t2 24.3773
R42 B.n1 B.t3 24.3773
R43 B.n0 B.t0 19.0326
R44 B.n1 B.t1 19.0326
R45 B.n2 B.n0 9.57582
R46 B.n2 B.n1 5.59401
R47 B B.n2 4.15011
R48 A.n0 A.t2 23.9862
R49 A.n1 A.t3 23.9862
R50 A.n0 A.t0 19.4237
R51 A.n1 A.t1 19.4237
R52 A.n2 A.n0 11.1875
R53 A A.n2 4.13024
R54 A.n2 A.n1 3.98232
R55 VNW.t3 VNW.t0 558.14
R56 VNW.t0 VNW.t1 310.079
R57 VNW.t2 VNW.t3 310.079
R58 VNW.t5 VNW.t2 310.079
R59 VNW.t4 VNW.t5 310.079
R60 VNW VNW.t4 259.69
R61 VPW.t3 VPW.t0 2127.27
R62 VPW.t0 VPW.t1 1181.82
R63 VPW.t2 VPW.t3 1181.82
R64 VPW.t5 VPW.t2 1181.82
R65 VPW.t4 VPW.t5 1181.82
R66 VPW VPW.t4 989.774
C0 VSS VDD 0.00597f
C1 VDD a_492_68# 0.02261f
C2 A B 0.07018f
C3 VNW a_28_68# 0.00249f
C4 VDD B 0.03491f
C5 VNW C 0.19155f
C6 VSS Y 0.0021f
C7 A VNW 0.17582f
C8 Y a_492_68# 0.14127f
C9 VDD VNW 0.19442f
C10 Y B 0.1775f
C11 A a_28_68# 0.14525f
C12 A C 0
C13 VSS a_492_68# 0.45371f
C14 VDD a_28_68# 0.0079f
C15 VDD C 0.05283f
C16 Y VNW 0.0859f
C17 VSS B 0.01922f
C18 a_492_68# B 0.13827f
C19 VDD A 0.07025f
C20 Y a_28_68# 0.02149f
C21 Y C 0.31482f
C22 VSS VNW 0.00367f
C23 VNW a_492_68# 0.00701f
C24 Y A 0.09117f
C25 VNW B 0.17603f
C26 Y VDD 0.73694f
C27 VSS a_28_68# 0.6122f
C28 a_492_68# a_28_68# 0.37892f
C29 VSS C 0.01838f
C30 a_492_68# C 0.06409f
C31 B a_28_68# 0.04664f
C32 VSS A 0.03119f
C33 A a_492_68# 0
C34 C B 0.03417f
C35 VSS VPW 1.39973f
C36 Y VPW 0.07366f
C37 VDD VPW -0.03141f
C38 C VPW 0.34325f
C39 B VPW 0.35376f
C40 A VPW 0.34059f
C41 VNW VPW 2.27055f
C42 a_492_68# VPW 0.03304f
C43 a_28_68# VPW 0.02522f
C44 VNW.t1 VPW 0.19432f
C45 VNW.t0 VPW 0.13352f
C46 VNW.t3 VPW 0.13352f
C47 VNW.t2 VPW 0.09537f
C48 VNW.t5 VPW 0.09537f
C49 VNW.t4 VPW 0.08762f
C50 A.t2 VPW 0.06769f
C51 A.t0 VPW 0.04749f
C52 A.n0 VPW 0.10413f
C53 A.t3 VPW 0.06769f
C54 A.t1 VPW 0.04749f
C55 A.n1 VPW 0.10563f
C56 A.n2 VPW 0.04246f
C57 B.t2 VPW 0.07812f
C58 B.t0 VPW 0.05375f
C59 B.n0 VPW 0.11434f
C60 B.t3 VPW 0.07812f
C61 B.t1 VPW 0.05375f
C62 B.n1 VPW 0.1258f
C63 B.n2 VPW 0.04981f
C64 C.t2 VPW 0.09218f
C65 C.t0 VPW 0.06706f
C66 C.n0 VPW 0.11112f
C67 C.t3 VPW 0.08933f
C68 C.t1 VPW 0.06449f
C69 C.n1 VPW 0.14666f
C70 VDD.t3 VPW 0.07324f
C71 VDD.n0 VPW 0.4116f
C72 VDD.t0 VPW 0.05429f
C73 VDD.t4 VPW 0.05429f
C74 VDD.n1 VPW 0.10858f
C75 VDD.n2 VPW 0.05842f
C76 VDD.t5 VPW 0.02434f
C77 VDD.t1 VPW 0.02434f
C78 VDD.n3 VPW 0.04881f
C79 VDD.t2 VPW 0.06604f
C80 VDD.n4 VPW 0.13565f
C81 VDD.n5 VPW 0.13757f
C82 VDD.n6 VPW 0.31828f
C83 Y.t1 VPW 0.06407f
C84 Y.t2 VPW 0.06407f
C85 Y.n0 VPW 0.158f
C86 Y.t6 VPW 0.06407f
C87 Y.t7 VPW 0.06407f
C88 Y.n1 VPW 0.12814f
C89 Y.n2 VPW 0.24674f
C90 Y.t4 VPW 0.06407f
C91 Y.t0 VPW 0.06407f
C92 Y.n3 VPW 0.12844f
C93 Y.n4 VPW 0.17466f
C94 Y.t3 VPW 0.04643f
C95 Y.t5 VPW 0.04643f
C96 Y.n5 VPW 0.09285f
C97 Y.n6 VPW 0.02916f
C98 Y.n7 VPW 0.11509f
C99 VSS.t0 VPW 0.03461f
C100 VSS.t1 VPW 0.03461f
C101 VSS.n0 VPW 0.093f
.ends

* NGSPICE file created from gf180mcu_as_sc_mcu7t3v3__nand4_2.ext - technology: gf180mcuD

.subckt gf180mcu_as_sc_mcu7t3v3__nand4_2 VDD VNW VPW VSS A B C D Y
X0 VDD.t5 A.t2 Y.t7 VNW.t7 pfet_03v3 ad=0.3588p pd=1.9u as=0.3588p ps=1.9u w=1.38u l=0.28u
X1 Y.t6 D.t1 a_796_68# VPW.t0 nfet_03v3 ad=0.26p pd=1.52u as=0.26p ps=1.52u w=1u l=0.28u
X2 VSS.t0 A.t1 a_28_68# VPW.t6 nfet_03v3 ad=0.26p pd=1.52u as=0.44p ps=2.88u w=1u l=0.28u
X3 VDD.t4 C.t2 Y.t5 VNW.t3 pfet_03v3 ad=0.3588p pd=1.9u as=0.3588p ps=1.9u w=1.38u l=0.28u
X4 a_796_68# C.t0 a_492_68# VPW.t3 nfet_03v3 ad=0.26p pd=1.52u as=0.26p ps=1.52u w=1u l=0.28u
X5 Y.t3 B.t3 VDD.t2 VNW.t4 pfet_03v3 ad=0.3588p pd=1.9u as=0.3588p ps=1.9u w=1.38u l=0.28u
X6 a_28_68# B.t0 a_492_68# VPW.t5 nfet_03v3 ad=0.44p pd=2.88u as=0.26p ps=1.52u w=1u l=0.28u
X7 Y.t4 D.t3 VDD.t3 VNW.t0 pfet_03v3 ad=0.3588p pd=1.9u as=0.3588p ps=1.9u w=1.38u l=0.28u
X8 VDD.t1 B.t2 Y.t2 VNW.t5 pfet_03v3 ad=0.8004p pd=2.54u as=0.3588p ps=1.9u w=1.38u l=0.28u
X9 Y.t9 C.t3 VDD.t7 VNW.t2 pfet_03v3 ad=0.3588p pd=1.9u as=0.8004p ps=2.54u w=1.38u l=0.28u
X10 a_492_68# C.t1 a_796_68# VPW.t2 nfet_03v3 ad=0.26p pd=1.52u as=0.44p ps=2.88u w=1u l=0.28u
X11 a_492_68# B.t1 a_28_68# VPW.t4 nfet_03v3 ad=0.26p pd=1.52u as=0.26p ps=1.52u w=1u l=0.28u
X12 VDD.t0 D.t2 Y.t1 VNW.t1 pfet_03v3 ad=0.6348p pd=3.68u as=0.3588p ps=1.9u w=1.38u l=0.28u
X13 Y.t8 A.t3 VDD.t6 VNW.t6 pfet_03v3 ad=0.3588p pd=1.9u as=0.6072p ps=3.64u w=1.38u l=0.28u
X14 a_796_68# D.t0 Y.t0 VPW.t1 nfet_03v3 ad=0.46p pd=2.92u as=0.26p ps=1.52u w=1u l=0.28u
X15 a_28_68# A.t0 VSS.t1 VPW.t7 nfet_03v3 ad=0.26p pd=1.52u as=0.26p ps=1.52u w=1u l=0.28u
R0 VSS VSS.n0 6.55459
R1 VSS.n0 VSS.t1 1.6385
R2 VSS.n0 VSS.t0 1.6385
R3 Y.n8 Y.n7 6.3005
R4 Y.n5 Y.n1 5.2005
R5 Y.n6 Y.n0 5.2005
R6 Y.n4 Y.n2 3.3655
R7 Y.n4 Y.n3 2.6005
R8 Y.n7 Y.t0 1.6385
R9 Y.n7 Y.t6 1.6385
R10 Y.n3 Y.t2 1.31934
R11 Y.n3 Y.t3 1.31934
R12 Y.n2 Y.t7 1.31934
R13 Y.n2 Y.t8 1.31934
R14 Y.n0 Y.t1 1.31934
R15 Y.n0 Y.t4 1.31934
R16 Y.n1 Y.t5 1.31934
R17 Y.n1 Y.t9 1.31934
R18 Y.n5 Y.n4 0.877022
R19 Y.n6 Y.n5 0.626587
R20 Y.n8 Y.n6 0.326784
R21 Y Y.n8 0.0360814
R22 VDD.n1 VDD.n0 5.28659
R23 VDD.n7 VDD.n5 5.28659
R24 VDD.n6 VDD.t6 4.18738
R25 VDD.n1 VDD.t0 3.57833
R26 VDD.n3 VDD.t7 2.94253
R27 VDD.n3 VDD.t1 2.94253
R28 VDD.n4 VDD.n3 2.6005
R29 VDD.n0 VDD.t3 1.31934
R30 VDD.n0 VDD.t4 1.31934
R31 VDD.n5 VDD.t2 1.31934
R32 VDD.n5 VDD.t5 1.31934
R33 VDD.n2 VDD 0.64175
R34 VDD VDD.n8 0.310045
R35 VDD.n7 VDD.n6 0.2405
R36 VDD.n2 VDD.n1 0.22325
R37 VDD.n8 VDD.n7 0.22325
R38 VDD.n6 VDD 0.0485
R39 VDD.n4 VDD.n2 0.0400455
R40 VDD.n8 VDD.n4 0.0400455
R41 D.n0 D.t2 29.0701
R42 D.n1 D.t3 26.7237
R43 D.n0 D.t0 24.3773
R44 D.n1 D.t1 22.091
R45 D.n1 D.n0 14.0598
R46 D D.n1 8.02273
R47 C.n0 C.t2 29.0701
R48 C.n1 C.t3 26.7237
R49 C.n0 C.t0 24.3773
R50 C.n1 C.t1 22.091
R51 C.n1 C.n0 16.5048
R52 C C.n1 8.04325
R53 B.n0 B.t2 24.3773
R54 B.n1 B.t3 24.3773
R55 B.n0 B.t0 19.0326
R56 B.n1 B.t1 19.0326
R57 B.n2 B.n0 9.57582
R58 B.n2 B.n1 5.59401
R59 B B.n2 4.15011
R60 A.n0 A.t2 23.9862
R61 A.n1 A.t3 23.9862
R62 A.n0 A.t0 19.4237
R63 A.n1 A.t1 19.4237
R64 A.n2 A.n0 11.1875
R65 A A.n2 4.13024
R66 A.n2 A.n1 3.98232
R67 VNW.t5 VNW.t2 558.14
R68 VNW.t0 VNW.t1 310.079
R69 VNW.t3 VNW.t0 310.079
R70 VNW.t2 VNW.t3 310.079
R71 VNW.t4 VNW.t5 310.079
R72 VNW.t7 VNW.t4 310.079
R73 VNW.t6 VNW.t7 310.079
R74 VNW VNW.t6 259.69
R75 VPW.t5 VPW.t2 2127.27
R76 VPW.t0 VPW.t1 1181.82
R77 VPW.t3 VPW.t0 1181.82
R78 VPW.t2 VPW.t3 1181.82
R79 VPW.t4 VPW.t5 1181.82
R80 VPW.t7 VPW.t4 1181.82
R81 VPW.t6 VPW.t7 1181.82
R82 VPW VPW.t6 989.774
C0 a_796_68# a_28_68# 0.03845f
C1 D B 0
C2 D VDD 0.04999f
C3 VSS A 0.03119f
C4 A a_492_68# 0
C5 D Y 0.31279f
C6 C D 0.07939f
C7 VSS B 0.01922f
C8 VSS VDD 0.00703f
C9 B a_492_68# 0.13676f
C10 VDD a_492_68# 0.00449f
C11 VSS Y 0.00189f
C12 VSS C 0.01817f
C13 Y a_492_68# 0.05507f
C14 VNW a_796_68# 0.00401f
C15 C a_492_68# 0.0674f
C16 VSS D 0.0176f
C17 D a_492_68# 0
C18 VNW a_28_68# 0.00249f
C19 VDD a_796_68# 0.01816f
C20 VSS a_492_68# 0.02388f
C21 A a_28_68# 0.14525f
C22 Y a_796_68# 0.13304f
C23 C a_796_68# 0.02332f
C24 B a_28_68# 0.04664f
C25 VDD a_28_68# 0.0079f
C26 D a_796_68# 0.05106f
C27 Y a_28_68# 0.02122f
C28 C a_28_68# 0
C29 A VNW 0.17582f
C30 VSS a_796_68# 0.8023f
C31 D a_28_68# 0
C32 a_796_68# a_492_68# 0.27187f
C33 VNW B 0.17603f
C34 VNW VDD 0.24359f
C35 VNW Y 0.08137f
C36 C VNW 0.18572f
C37 VSS a_28_68# 0.6122f
C38 a_492_68# a_28_68# 0.34196f
C39 A B 0.07018f
C40 A VDD 0.07025f
C41 A Y 0.09097f
C42 VNW D 0.17897f
C43 C A 0
C44 B VDD 0.03499f
C45 B Y 0.17587f
C46 VDD Y 0.82249f
C47 C B 0.0342f
C48 VSS VNW 0.00437f
C49 C VDD 0.0421f
C50 VNW a_492_68# 0.00779f
C51 C Y 0.1388f
C52 VSS VPW 1.86386f
C53 Y VPW 0.06719f
C54 VDD VPW 0.05359f
C55 D VPW 0.33171f
C56 C VPW 0.30562f
C57 B VPW 0.35322f
C58 A VPW 0.34055f
C59 VNW VPW 2.79283f
C60 a_796_68# VPW 0.01663f
C61 a_492_68# VPW 0.01546f
C62 a_28_68# VPW 0.02695f
C63 VNW.t1 VPW 0.20838f
C64 VNW.t0 VPW 0.09749f
C65 VNW.t3 VPW 0.09749f
C66 VNW.t2 VPW 0.13648f
C67 VNW.t5 VPW 0.13648f
C68 VNW.t4 VPW 0.09749f
C69 VNW.t7 VPW 0.09749f
C70 VNW.t6 VPW 0.08957f
C71 A.t2 VPW 0.06767f
C72 A.t0 VPW 0.04748f
C73 A.n0 VPW 0.10409f
C74 A.t3 VPW 0.06767f
C75 A.t1 VPW 0.04748f
C76 A.n1 VPW 0.10559f
C77 A.n2 VPW 0.04245f
C78 B.t2 VPW 0.07778f
C79 B.t0 VPW 0.05351f
C80 B.n0 VPW 0.11384f
C81 B.t3 VPW 0.07778f
C82 B.t1 VPW 0.05351f
C83 B.n1 VPW 0.12525f
C84 B.n2 VPW 0.04959f
C85 C.t2 VPW 0.08042f
C86 C.t0 VPW 0.05851f
C87 C.n0 VPW 0.09694f
C88 C.t3 VPW 0.07793f
C89 C.t1 VPW 0.05626f
C90 C.n1 VPW 0.12794f
C91 D.t2 VPW 0.0932f
C92 D.t0 VPW 0.0678f
C93 D.n0 VPW 0.11571f
C94 D.t3 VPW 0.09031f
C95 D.t1 VPW 0.0652f
C96 D.n1 VPW 0.15136f
C97 VDD.t3 VPW 0.02301f
C98 VDD.t4 VPW 0.02301f
C99 VDD.n0 VPW 0.04616f
C100 VDD.t0 VPW 0.07202f
C101 VDD.n1 VPW 0.28138f
C102 VDD.n2 VPW 0.24928f
C103 VDD.t7 VPW 0.05133f
C104 VDD.t1 VPW 0.05133f
C105 VDD.n3 VPW 0.10267f
C106 VDD.n4 VPW 0.05524f
C107 VDD.t2 VPW 0.02301f
C108 VDD.t5 VPW 0.02301f
C109 VDD.n5 VPW 0.04616f
C110 VDD.t6 VPW 0.06245f
C111 VDD.n6 VPW 0.12827f
C112 VDD.n7 VPW 0.13009f
C113 VDD.n8 VPW 0.30097f
C114 Y.t1 VPW 0.05954f
C115 Y.t4 VPW 0.05954f
C116 Y.n0 VPW 0.11907f
C117 Y.t5 VPW 0.05954f
C118 Y.t9 VPW 0.05954f
C119 Y.n1 VPW 0.11907f
C120 Y.t7 VPW 0.05954f
C121 Y.t8 VPW 0.05954f
C122 Y.n2 VPW 0.14682f
C123 Y.t2 VPW 0.05954f
C124 Y.t3 VPW 0.05954f
C125 Y.n3 VPW 0.11907f
C126 Y.n4 VPW 0.23368f
C127 Y.n5 VPW 0.15953f
C128 Y.n6 VPW 0.15273f
C129 Y.t0 VPW 0.04314f
C130 Y.t6 VPW 0.04314f
C131 Y.n7 VPW 0.08628f
C132 Y.n8 VPW 0.12253f
C133 VSS.t1 VPW 0.03762f
C134 VSS.t0 VPW 0.03762f
C135 VSS.n0 VPW 0.10856f
.ends

* NGSPICE file created from gf180mcu_as_sc_mcu7t3v3__nor2_2.ext - technology: gf180mcuD

.subckt gf180mcu_as_sc_mcu7t3v3__nor2_2 VDD VNW VPW VSS Y B A
X0 a_28_440# A.t2 VDD.t1 VNW.t3 pfet_03v3 ad=0.3588p pd=1.9u as=0.3588p ps=1.9u w=1.38u l=0.28u
X1 Y.t0 A.t1 VSS.t0 VPW.t2 nfet_03v3 ad=0.26p pd=1.52u as=0.44p ps=2.88u w=1u l=0.28u
X2 Y.t4 B.t3 a_28_440# VNW.t0 pfet_03v3 ad=0.3588p pd=1.9u as=0.3588p ps=1.9u w=1.38u l=0.28u
X3 VSS.t3 B.t0 Y.t5 VPW.t1 nfet_03v3 ad=0.515p pd=3.03u as=0.26p ps=1.52u w=1u l=0.28u
X4 a_28_440# B.t2 Y.t1 VNW.t1 pfet_03v3 ad=0.7176p pd=3.8u as=0.3588p ps=1.9u w=1.38u l=0.28u
X5 Y.t3 B.t1 VSS.t2 VPW.t0 nfet_03v3 ad=0.26p pd=1.52u as=0.26p ps=1.52u w=1u l=0.28u
X6 VDD.t0 A.t3 a_28_440# VNW.t2 pfet_03v3 ad=0.3588p pd=1.9u as=0.6072p ps=3.64u w=1.38u l=0.28u
X7 VSS.t1 A.t0 Y.t2 VPW.t3 nfet_03v3 ad=0.26p pd=1.52u as=0.26p ps=1.52u w=1u l=0.28u
R0 VSS.n2 VSS.t0 10.9684
R1 VSS.n1 VSS.t3 10.5412
R2 VSS.n1 VSS.n0 6.38659
R3 VSS.n0 VSS.t2 1.6385
R4 VSS.n0 VSS.t1 1.6385
R5 VSS.n2 VSS.n1 0.2405
R6 VSS VSS.n2 0.0485
R7 Y.n2 Y.n0 6.91203
R8 Y.n2 Y.n1 6.3005
R9 Y.n4 Y.n3 5.58532
R10 Y.n1 Y.t5 1.6385
R11 Y.n1 Y.t3 1.6385
R12 Y.n0 Y.t2 1.6385
R13 Y.n0 Y.t0 1.6385
R14 Y.n3 Y.t1 1.31934
R15 Y.n3 Y.t4 1.31934
R16 Y.n4 Y.n2 0.140941
R17 Y Y.n4 0.0263511
R18 VDD VDD.n0 5.45459
R19 VDD.n0 VDD.t1 1.31934
R20 VDD.n0 VDD.t0 1.31934
R21 B.n0 B.t2 22.813
R22 B.n1 B.t3 22.813
R23 B.n0 B.t0 20.0755
R24 B.n1 B.t1 20.0755
R25 B.n2 B.n0 10.0042
R26 B.n2 B.n1 4.41655
R27 B B.n2 4.09717
R28 A.n0 A.t2 22.6826
R29 A.n1 A.t3 22.6826
R30 A.n0 A.t0 20.2059
R31 A.n1 A.t1 20.2059
R32 A.n2 A.n0 7.93136
R33 A.n2 A.n1 6.48939
R34 A A.n2 4.12939
R35 VNW.t0 VNW.t1 310.079
R36 VNW.t3 VNW.t0 310.079
R37 VNW.t2 VNW.t3 310.079
R38 VNW VNW.t2 259.69
R39 VPW.t0 VPW.t1 1181.82
R40 VPW.t3 VPW.t0 1181.82
R41 VPW.t2 VPW.t3 1181.82
R42 VPW VPW.t2 989.774
C0 Y VSS 0.23301f
C1 a_28_440# VSS 0.01145f
C2 VNW VDD 0.09614f
C3 Y A 0.11413f
C4 a_28_440# A 0.11018f
C5 B VDD 0.01806f
C6 VSS VDD 0.00605f
C7 a_28_440# Y 0.12171f
C8 A VDD 0.03386f
C9 VNW B 0.16538f
C10 VNW VSS 0.00453f
C11 Y VDD 0.00422f
C12 a_28_440# VDD 0.60304f
C13 VSS B 0.03342f
C14 VNW A 0.16954f
C15 VNW Y 0.02012f
C16 VNW a_28_440# 0.0191f
C17 A B 0.0705f
C18 VSS A 0.05287f
C19 Y B 0.3525f
C20 a_28_440# B 0.04418f
C21 VSS VPW 0.31407f
C22 Y VPW 0.09897f
C23 VDD VPW 0.77329f
C24 B VPW 0.31605f
C25 A VPW 0.33988f
C26 VNW VPW 1.56085f
C27 a_28_440# VPW 0.03131f
C28 VNW.t1 VPW 0.16192f
C29 VNW.t0 VPW 0.07947f
C30 VNW.t3 VPW 0.07947f
C31 VNW.t2 VPW 0.07301f
C32 A.t2 VPW 0.06123f
C33 A.t0 VPW 0.04516f
C34 A.n0 VPW 0.09087f
C35 A.t3 VPW 0.06123f
C36 A.t1 VPW 0.04516f
C37 A.n1 VPW 0.09479f
C38 A.n2 VPW 0.0418f
C39 B.t2 VPW 0.0818f
C40 B.t0 VPW 0.05994f
C41 B.n0 VPW 0.12857f
C42 B.t3 VPW 0.0818f
C43 B.t1 VPW 0.05994f
C44 B.n1 VPW 0.11488f
C45 B.n2 VPW 0.05395f
C46 VDD.t1 VPW 0.04323f
C47 VDD.t0 VPW 0.04323f
C48 VDD.n0 VPW 0.10234f
C49 Y.t2 VPW 0.03499f
C50 Y.t0 VPW 0.03499f
C51 Y.n0 VPW 0.07429f
C52 Y.t5 VPW 0.03499f
C53 Y.t3 VPW 0.03499f
C54 Y.n1 VPW 0.06997f
C55 Y.n2 VPW 0.11721f
C56 Y.t1 VPW 0.04828f
C57 Y.t4 VPW 0.04828f
C58 Y.n3 VPW 0.10327f
C59 Y.n4 VPW 0.2359f
C60 VSS.t0 VPW 0.0315f
C61 VSS.t2 VPW 0.01083f
C62 VSS.t1 VPW 0.01083f
C63 VSS.n0 VPW 0.02174f
C64 VSS.t3 VPW 0.03908f
C65 VSS.n1 VPW 0.15871f
C66 VSS.n2 VPW 0.06064f
.ends

* NGSPICE file created from gf180mcu_as_sc_mcu7t3v3__nor2_4.ext - technology: gf180mcuD

.subckt gf180mcu_as_sc_mcu7t3v3__nor2_4 VDD VNW VPW VSS Y A B
X0 VSS.t4 B.t2 Y.t4 VPW.t1 nfet_03v3 ad=0.26p pd=1.52u as=0.26p ps=1.52u w=1u l=0.28u
X1 a_28_440# A.t6 VDD.t2 VNW.t5 pfet_03v3 ad=0.3588p pd=1.9u as=0.3588p ps=1.9u w=1.38u l=0.28u
X2 Y.t9 B.t7 a_28_440# VNW.t0 pfet_03v3 ad=0.3588p pd=1.9u as=0.3588p ps=1.9u w=1.38u l=0.28u
X3 Y.t11 A.t3 VSS.t7 VPW.t4 nfet_03v3 ad=0.26p pd=1.52u as=0.44p ps=2.88u w=1u l=0.28u
X4 a_28_440# B.t4 Y.t6 VNW.t3 pfet_03v3 ad=0.9384p pd=4.12u as=0.3588p ps=1.9u w=1.38u l=0.28u
X5 Y.t5 B.t3 VSS.t5 VPW.t0 nfet_03v3 ad=0.26p pd=1.52u as=0.26p ps=1.52u w=1u l=0.28u
X6 VDD.t1 A.t5 a_28_440# VNW.t6 pfet_03v3 ad=0.3588p pd=1.9u as=0.3588p ps=1.9u w=1.38u l=0.28u
X7 a_28_440# B.t6 Y.t8 VNW.t1 pfet_03v3 ad=0.3588p pd=1.9u as=0.3588p ps=1.9u w=1.38u l=0.28u
X8 VSS.t0 A.t0 Y.t0 VPW.t7 nfet_03v3 ad=0.26p pd=1.52u as=0.26p ps=1.52u w=1u l=0.28u
X9 VSS.t3 B.t0 Y.t3 VPW.t3 nfet_03v3 ad=0.68p pd=3.36u as=0.26p ps=1.52u w=1u l=0.28u
X10 a_28_440# A.t4 VDD.t0 VNW.t7 pfet_03v3 ad=0.3588p pd=1.9u as=0.3588p ps=1.9u w=1.38u l=0.28u
X11 Y.t2 A.t1 VSS.t2 VPW.t6 nfet_03v3 ad=0.26p pd=1.52u as=0.26p ps=1.52u w=1u l=0.28u
X12 Y.t7 B.t5 a_28_440# VNW.t2 pfet_03v3 ad=0.3588p pd=1.9u as=0.3588p ps=1.9u w=1.38u l=0.28u
X13 Y.t1 B.t1 VSS.t1 VPW.t2 nfet_03v3 ad=0.26p pd=1.52u as=0.26p ps=1.52u w=1u l=0.28u
X14 VDD.t3 A.t7 a_28_440# VNW.t4 pfet_03v3 ad=0.3588p pd=1.9u as=0.6072p ps=3.64u w=1.38u l=0.28u
X15 VSS.t6 A.t2 Y.t10 VPW.t5 nfet_03v3 ad=0.26p pd=1.52u as=0.26p ps=1.52u w=1u l=0.28u
R0 VSS.n3 VSS.n2 6.38659
R1 VSS.n4 VSS.n1 6.38659
R2 VSS.n5 VSS.n0 6.38659
R3 VSS.n3 VSS.t3 5.2398
R4 VSS.n6 VSS.t7 4.9998
R5 VSS.n2 VSS.t1 1.6385
R6 VSS.n2 VSS.t4 1.6385
R7 VSS.n1 VSS.t5 1.6385
R8 VSS.n1 VSS.t0 1.6385
R9 VSS.n0 VSS.t2 1.6385
R10 VSS.n0 VSS.t6 1.6385
R11 VSS.n4 VSS.n3 0.2405
R12 VSS.n5 VSS.n4 0.2405
R13 VSS.n6 VSS.n5 0.2405
R14 VSS VSS.n6 0.0485
R15 Y.n2 Y.n0 6.92659
R16 Y.n4 Y.n3 6.3005
R17 Y.n2 Y.n1 6.3005
R18 Y.n9 Y.n8 6.3005
R19 Y.n7 Y.n5 5.74246
R20 Y.n7 Y.n6 5.2005
R21 Y.n8 Y.t3 1.6385
R22 Y.n8 Y.t1 1.6385
R23 Y.n0 Y.t10 1.6385
R24 Y.n0 Y.t11 1.6385
R25 Y.n1 Y.t0 1.6385
R26 Y.n1 Y.t2 1.6385
R27 Y.n3 Y.t4 1.6385
R28 Y.n3 Y.t5 1.6385
R29 Y.n6 Y.t6 1.31934
R30 Y.n6 Y.t7 1.31934
R31 Y.n5 Y.t8 1.31934
R32 Y.n5 Y.t9 1.31934
R33 Y.n4 Y.n2 0.626587
R34 Y.n9 Y.n4 0.542457
R35 Y.n9 Y.n7 0.322826
R36 Y Y.n9 0.0245698
R37 VDD.n2 VDD.n1 5.52659
R38 VDD.n2 VDD.n0 5.28659
R39 VDD.n0 VDD.t2 1.31934
R40 VDD.n0 VDD.t3 1.31934
R41 VDD.n1 VDD.t0 1.31934
R42 VDD.n1 VDD.t1 1.31934
R43 VDD VDD.n2 0.1685
R44 B.n0 B.t4 24.1166
R45 B.n1 B.t5 24.1166
R46 B.n2 B.t6 24.1166
R47 B.n3 B.t7 24.1166
R48 B.n0 B.t0 19.4237
R49 B.n1 B.t1 19.4237
R50 B.n2 B.t2 19.4237
R51 B.n3 B.t3 19.4237
R52 B.n1 B.n0 15.3689
R53 B.n2 B.n1 15.3689
R54 B.n4 B.n3 14.3123
R55 B B.n4 2.84074
R56 B.n4 B.n2 1.05708
R57 A.n0 A.t4 24.1166
R58 A.n1 A.t5 24.1166
R59 A.n3 A.t6 24.1166
R60 A.n2 A.t7 24.1166
R61 A.n0 A.t0 19.4237
R62 A.n1 A.t1 19.4237
R63 A.n3 A.t2 19.4237
R64 A.n2 A.t3 19.4237
R65 A.n1 A.n0 15.3689
R66 A.n3 A.n2 15.3689
R67 A.n4 A.n1 7.68471
R68 A.n4 A.n3 7.68471
R69 A A.n4 1.88097
R70 VNW.t2 VNW.t3 310.079
R71 VNW.t1 VNW.t2 310.079
R72 VNW.t0 VNW.t1 310.079
R73 VNW.t7 VNW.t0 310.079
R74 VNW.t6 VNW.t7 310.079
R75 VNW.t5 VNW.t6 310.079
R76 VNW.t4 VNW.t5 310.079
R77 VNW VNW.t4 259.69
R78 VPW.t2 VPW.t3 1181.82
R79 VPW.t1 VPW.t2 1181.82
R80 VPW.t0 VPW.t1 1181.82
R81 VPW.t7 VPW.t0 1181.82
R82 VPW.t6 VPW.t7 1181.82
R83 VPW.t5 VPW.t6 1181.82
R84 VPW.t4 VPW.t5 1181.82
R85 VPW VPW.t4 989.774
C0 Y B 0.56147f
C1 Y VDD 0.0052f
C2 a_28_440# B 0.06231f
C3 VDD a_28_440# 1.07284f
C4 VSS B 0.08116f
C5 Y VNW 0.02507f
C6 VSS VDD 0.00876f
C7 a_28_440# VNW 0.08077f
C8 VSS VNW 0.00749f
C9 Y a_28_440# 0.34799f
C10 VSS Y 0.57773f
C11 VSS a_28_440# 0.03538f
C12 B A 0.06274f
C13 VDD A 0.0721f
C14 A VNW 0.3442f
C15 VDD B 0.03573f
C16 Y A 0.38389f
C17 a_28_440# A 0.38461f
C18 B VNW 0.34158f
C19 VDD VNW 0.1656f
C20 VSS A 0.08175f
C21 VSS VPW 0.55752f
C22 Y VPW 0.0673f
C23 VDD VPW 0.39916f
C24 B VPW 0.59279f
C25 A VPW 0.71979f
C26 VNW VPW 2.61673f
C27 a_28_440# VPW 0.04893f
C28 VNW.t3 VPW 0.21214f
C29 VNW.t2 VPW 0.09481f
C30 VNW.t1 VPW 0.09481f
C31 VNW.t0 VPW 0.09481f
C32 VNW.t7 VPW 0.09481f
C33 VNW.t6 VPW 0.09481f
C34 VNW.t5 VPW 0.09481f
C35 VNW.t4 VPW 0.08711f
C36 A.t5 VPW 0.0711f
C37 A.t1 VPW 0.04975f
C38 A.t4 VPW 0.0711f
C39 A.t0 VPW 0.04975f
C40 A.n0 VPW 0.11955f
C41 A.n1 VPW 0.12576f
C42 A.t6 VPW 0.0711f
C43 A.t2 VPW 0.04975f
C44 A.t7 VPW 0.0711f
C45 A.t3 VPW 0.04975f
C46 A.n2 VPW 0.11955f
C47 A.n3 VPW 0.12576f
C48 A.n4 VPW 0.0765f
C49 B.t6 VPW 0.06774f
C50 B.t2 VPW 0.0474f
C51 B.t5 VPW 0.06774f
C52 B.t1 VPW 0.0474f
C53 B.t4 VPW 0.06774f
C54 B.t0 VPW 0.0474f
C55 B.n0 VPW 0.11489f
C56 B.n1 VPW 0.13954f
C57 B.n2 VPW 0.10281f
C58 B.t7 VPW 0.06774f
C59 B.t3 VPW 0.0474f
C60 B.n3 VPW 0.11119f
C61 B.n4 VPW 0.04753f
C62 VDD.t2 VPW 0.04079f
C63 VDD.t3 VPW 0.04079f
C64 VDD.n0 VPW 0.08182f
C65 VDD.t0 VPW 0.04079f
C66 VDD.t1 VPW 0.04079f
C67 VDD.n1 VPW 0.11445f
C68 VDD.n2 VPW 0.92442f
C69 Y.t10 VPW 0.04243f
C70 Y.t11 VPW 0.04243f
C71 Y.n0 VPW 0.09294f
C72 Y.t0 VPW 0.04243f
C73 Y.t2 VPW 0.04243f
C74 Y.n1 VPW 0.08487f
C75 Y.n2 VPW 0.20138f
C76 Y.t4 VPW 0.04243f
C77 Y.t5 VPW 0.04243f
C78 Y.n3 VPW 0.08487f
C79 Y.n4 VPW 0.11205f
C80 Y.t8 VPW 0.05856f
C81 Y.t9 VPW 0.05856f
C82 Y.n5 VPW 0.12447f
C83 Y.t6 VPW 0.05856f
C84 Y.t7 VPW 0.05856f
C85 Y.n6 VPW 0.11712f
C86 Y.n7 VPW 0.24885f
C87 Y.t3 VPW 0.04243f
C88 Y.t1 VPW 0.04243f
C89 Y.n8 VPW 0.08487f
C90 Y.n9 VPW 0.16814f
C91 VSS.t7 VPW 0.03512f
C92 VSS.t2 VPW 0.01319f
C93 VSS.t6 VPW 0.01319f
C94 VSS.n0 VPW 0.02647f
C95 VSS.t5 VPW 0.01319f
C96 VSS.t0 VPW 0.01319f
C97 VSS.n1 VPW 0.02647f
C98 VSS.t1 VPW 0.01319f
C99 VSS.t4 VPW 0.01319f
C100 VSS.n2 VPW 0.02647f
C101 VSS.t3 VPW 0.05723f
C102 VSS.n3 VPW 0.22591f
C103 VSS.n4 VPW 0.10641f
C104 VSS.n5 VPW 0.10641f
C105 VSS.n6 VPW 0.09292f
.ends

* NGSPICE file created from gf180mcu_as_sc_mcu7t3v3__nor2b_2.ext - technology: gf180mcuD

.subckt gf180mcu_as_sc_mcu7t3v3__nor2b_2 VDD VNW VPW VSS Y B A
X0 VSS.t2 a_220_68# Y.t4 VPW.t3 nfet_03v3 ad=0.26p pd=1.52u as=0.26p ps=1.52u w=1u l=0.28u
X1 a_220_68# A.t0 VSS.t0 VPW.t4 nfet_03v3 ad=0.44p pd=2.88u as=0.445p ps=2.89u w=1u l=0.28u
X2 Y.t3 a_220_68# VSS.t3 VPW.t2 nfet_03v3 ad=0.26p pd=1.52u as=0.44p ps=2.88u w=1u l=0.28u
X3 a_220_68# A.t1 VDD.t0 VNW.t4 pfet_03v3 ad=0.6072p pd=3.64u as=0.6141p ps=3.65u w=1.38u l=0.28u
X4 VDD.t1 a_220_68# a_364_440# VNW.t2 pfet_03v3 ad=0.3588p pd=1.9u as=0.6072p ps=3.64u w=1.38u l=0.28u
X5 a_364_440# B.t2 Y.t1 VNW.t1 pfet_03v3 ad=0.7176p pd=3.8u as=0.3588p ps=1.9u w=1.38u l=0.28u
X6 VSS.t4 B.t0 Y.t5 VPW.t1 nfet_03v3 ad=0.515p pd=3.03u as=0.26p ps=1.52u w=1u l=0.28u
X7 a_364_440# a_220_68# VDD.t2 VNW.t3 pfet_03v3 ad=0.3588p pd=1.9u as=0.3588p ps=1.9u w=1.38u l=0.28u
X8 Y.t0 B.t1 VSS.t1 VPW.t0 nfet_03v3 ad=0.26p pd=1.52u as=0.26p ps=1.52u w=1u l=0.28u
X9 Y.t2 B.t3 a_364_440# VNW.t0 pfet_03v3 ad=0.3588p pd=1.9u as=0.3588p ps=1.9u w=1.38u l=0.28u
R0 VSS.n2 VSS.t3 10.9684
R1 VSS.n1 VSS.t4 10.5412
R2 VSS.n1 VSS.n0 6.38659
R3 VSS.n3 VSS.t0 4.98807
R4 VSS.n0 VSS.t1 1.6385
R5 VSS.n0 VSS.t2 1.6385
R6 VSS.n2 VSS.n1 0.2405
R7 VSS.n3 VSS.n2 0.2165
R8 VSS VSS.n3 0.0845
R9 Y.n2 Y.n0 6.92659
R10 Y.n2 Y.n1 6.3005
R11 Y.n4 Y.n3 5.67527
R12 Y.n0 Y.t4 1.6385
R13 Y.n0 Y.t3 1.6385
R14 Y.n1 Y.t5 1.6385
R15 Y.n1 Y.t0 1.6385
R16 Y.n3 Y.t1 1.31934
R17 Y.n3 Y.t2 1.31934
R18 Y.n4 Y.n2 0.17463
R19 Y Y.n4 0.0215638
R20 VDD.n1 VDD.n0 5.62259
R21 VDD.n1 VDD.t0 4.13065
R22 VDD.n0 VDD.t2 1.31934
R23 VDD.n0 VDD.t1 1.31934
R24 VDD VDD.n1 0.0845
R25 B.n0 B.t2 22.813
R26 B.n1 B.t3 22.813
R27 B.n0 B.t0 20.0755
R28 B.n1 B.t1 20.0755
R29 B.n2 B.n0 10.0042
R30 B.n2 B.n1 4.41655
R31 B B.n2 4.20383
R32 A.n0 A.t1 27.2451
R33 A.n0 A.t0 22.9434
R34 A.n1 A.n0 8.05597
R35 A.n1 A 0.0420385
R36 A A.n1 0.0381744
R37 VNW.t4 VNW.t2 558.14
R38 VNW VNW.t4 352.714
R39 VNW.t0 VNW.t1 310.079
R40 VNW.t3 VNW.t0 310.079
R41 VNW.t2 VNW.t3 310.079
R42 VPW.t4 VPW.t2 2127.27
R43 VPW VPW.t4 1344.32
R44 VPW.t0 VPW.t1 1181.82
R45 VPW.t3 VPW.t0 1181.82
R46 VPW.t2 VPW.t3 1181.82
C0 a_220_68# A 0.15093f
C1 VSS VNW 0.00628f
C2 Y VSS 0.23437f
C3 A VDD 0.09275f
C4 Y VNW 0.02309f
C5 VSS a_364_440# 0.00521f
C6 a_364_440# VNW 0.01391f
C7 a_220_68# VSS 0.13365f
C8 Y a_364_440# 0.26328f
C9 B VSS 0.03417f
C10 a_220_68# VNW 0.21663f
C11 B VNW 0.16855f
C12 Y a_220_68# 0.05156f
C13 Y B 0.37246f
C14 VDD VSS 0.01261f
C15 a_220_68# a_364_440# 0.1327f
C16 VDD VNW 0.16084f
C17 A VSS 0.09176f
C18 B a_364_440# 0.0726f
C19 Y VDD 0.00647f
C20 A VNW 0.10016f
C21 Y A 0
C22 a_220_68# B 0.06312f
C23 VDD a_364_440# 0.60388f
C24 a_220_68# VDD 0.17705f
C25 B VDD 0.01806f
C26 VSS VPW 0.45757f
C27 Y VPW 0.08992f
C28 VDD VPW 0.32126f
C29 B VPW 0.37536f
C30 A VPW 0.17231f
C31 VNW VPW 2.09981f
C32 a_364_440# VPW 0.01304f
C33 a_220_68# VPW 0.22921f
C34 VNW.t1 VPW 0.17397f
C35 VNW.t0 VPW 0.08538f
C36 VNW.t3 VPW 0.08538f
C37 VNW.t2 VPW 0.11954f
C38 VNW.t4 VPW 0.1254f
C39 A.t1 VPW 0.10045f
C40 A.t0 VPW 0.07316f
C41 A.n0 VPW 0.12597f
C42 A.n1 VPW 0.10973f
C43 B.t2 VPW 0.07987f
C44 B.t0 VPW 0.05852f
C45 B.n0 VPW 0.12553f
C46 B.t3 VPW 0.07987f
C47 B.t1 VPW 0.05852f
C48 B.n1 VPW 0.11216f
C49 B.n2 VPW 0.05601f
C50 VDD.t0 VPW 0.10342f
C51 VDD.t2 VPW 0.03832f
C52 VDD.t1 VPW 0.03832f
C53 VDD.n0 VPW 0.10802f
C54 VDD.n1 VPW 0.74769f
C55 Y.t4 VPW 0.03796f
C56 Y.t3 VPW 0.03796f
C57 Y.n0 VPW 0.08082f
C58 Y.t5 VPW 0.03796f
C59 Y.t0 VPW 0.03796f
C60 Y.n1 VPW 0.07593f
C61 Y.n2 VPW 0.11786f
C62 Y.t1 VPW 0.05239f
C63 Y.t2 VPW 0.05239f
C64 Y.n3 VPW 0.11497f
C65 Y.n4 VPW 0.29689f
C66 VSS.t0 VPW 0.03123f
C67 VSS.t3 VPW 0.03387f
C68 VSS.t1 VPW 0.01165f
C69 VSS.t2 VPW 0.01165f
C70 VSS.n0 VPW 0.02337f
C71 VSS.t4 VPW 0.04201f
C72 VSS.n1 VPW 0.17063f
C73 VSS.n2 VPW 0.0953f
C74 VSS.n3 VPW 0.08331f
.ends

* NGSPICE file created from gf180mcu_as_sc_mcu7t3v3__nor2b_4.ext - technology: gf180mcuD

.subckt gf180mcu_as_sc_mcu7t3v3__nor2b_4 VDD VNW VPW VSS Y A B
X0 a_364_440# B.t6 Y.t10 VNW.t5 pfet_03v3 ad=0.3588p pd=1.9u as=0.3588p ps=1.9u w=1.38u l=0.28u
X1 VSS.t3 a_220_68# Y.t3 VPW.t1 nfet_03v3 ad=0.26p pd=1.52u as=0.26p ps=1.52u w=1u l=0.28u
X2 VSS.t6 B.t2 Y.t6 VPW.t5 nfet_03v3 ad=0.26p pd=1.52u as=0.26p ps=1.52u w=1u l=0.28u
X3 a_220_68# A.t0 VSS.t1 VPW.t8 nfet_03v3 ad=0.44p pd=2.88u as=0.445p ps=2.89u w=1u l=0.28u
X4 Y.t2 a_220_68# VSS.t2 VPW.t0 nfet_03v3 ad=0.26p pd=1.52u as=0.44p ps=2.88u w=1u l=0.28u
X5 a_220_68# A.t1 VDD.t4 VNW.t8 pfet_03v3 ad=0.6072p pd=3.64u as=0.6141p ps=3.65u w=1.38u l=0.28u
X6 VDD.t0 a_220_68# a_364_440# VNW.t0 pfet_03v3 ad=0.3588p pd=1.9u as=0.6072p ps=3.64u w=1.38u l=0.28u
X7 a_364_440# a_220_68# VDD.t3 VNW.t3 pfet_03v3 ad=0.3588p pd=1.9u as=0.3588p ps=1.9u w=1.38u l=0.28u
X8 Y.t9 B.t3 VSS.t8 VPW.t4 nfet_03v3 ad=0.26p pd=1.52u as=0.26p ps=1.52u w=1u l=0.28u
X9 Y.t8 B.t5 a_364_440# VNW.t6 pfet_03v3 ad=0.3588p pd=1.9u as=0.3588p ps=1.9u w=1.38u l=0.28u
X10 Y.t11 B.t7 a_364_440# VNW.t4 pfet_03v3 ad=0.3588p pd=1.9u as=0.3588p ps=1.9u w=1.38u l=0.28u
X11 a_364_440# B.t4 Y.t0 VNW.t7 pfet_03v3 ad=0.9384p pd=4.12u as=0.3588p ps=1.9u w=1.38u l=0.28u
X12 VSS.t5 a_220_68# Y.t5 VPW.t3 nfet_03v3 ad=0.26p pd=1.52u as=0.26p ps=1.52u w=1u l=0.28u
X13 VSS.t7 B.t0 Y.t7 VPW.t7 nfet_03v3 ad=0.68p pd=3.36u as=0.26p ps=1.52u w=1u l=0.28u
X14 a_364_440# a_220_68# VDD.t1 VNW.t1 pfet_03v3 ad=0.3588p pd=1.9u as=0.3588p ps=1.9u w=1.38u l=0.28u
X15 Y.t4 a_220_68# VSS.t4 VPW.t2 nfet_03v3 ad=0.26p pd=1.52u as=0.26p ps=1.52u w=1u l=0.28u
X16 Y.t1 B.t1 VSS.t0 VPW.t6 nfet_03v3 ad=0.26p pd=1.52u as=0.26p ps=1.52u w=1u l=0.28u
X17 VDD.t2 a_220_68# a_364_440# VNW.t2 pfet_03v3 ad=0.3588p pd=1.9u as=0.3588p ps=1.9u w=1.38u l=0.28u
R0 VSS.n3 VSS.n2 6.38659
R1 VSS.n4 VSS.n1 6.38659
R2 VSS.n5 VSS.n0 6.38659
R3 VSS.n3 VSS.t7 5.2398
R4 VSS.n6 VSS.t2 4.9998
R5 VSS.n7 VSS.t1 4.98807
R6 VSS.n2 VSS.t0 1.6385
R7 VSS.n2 VSS.t6 1.6385
R8 VSS.n1 VSS.t8 1.6385
R9 VSS.n1 VSS.t5 1.6385
R10 VSS.n0 VSS.t4 1.6385
R11 VSS.n0 VSS.t3 1.6385
R12 VSS.n4 VSS.n3 0.2405
R13 VSS.n5 VSS.n4 0.2405
R14 VSS.n6 VSS.n5 0.2405
R15 VSS.n7 VSS.n6 0.2165
R16 VSS VSS.n7 0.0845
R17 Y.n2 Y.n0 6.92659
R18 Y.n4 Y.n3 6.3005
R19 Y.n2 Y.n1 6.3005
R20 Y.n9 Y.n8 6.3005
R21 Y.n7 Y.n5 5.74246
R22 Y.n7 Y.n6 5.2005
R23 Y.n8 Y.t7 1.6385
R24 Y.n8 Y.t1 1.6385
R25 Y.n0 Y.t3 1.6385
R26 Y.n0 Y.t2 1.6385
R27 Y.n1 Y.t5 1.6385
R28 Y.n1 Y.t4 1.6385
R29 Y.n3 Y.t6 1.6385
R30 Y.n3 Y.t9 1.6385
R31 Y.n6 Y.t0 1.31934
R32 Y.n6 Y.t8 1.31934
R33 Y.n5 Y.t10 1.31934
R34 Y.n5 Y.t11 1.31934
R35 Y.n4 Y.n2 0.626587
R36 Y.n9 Y.n4 0.542457
R37 Y.n9 Y.n7 0.322826
R38 Y Y.n9 0.0245698
R39 VDD.n2 VDD.n1 5.52659
R40 VDD.n2 VDD.n0 5.28659
R41 VDD.n3 VDD.t4 4.12673
R42 VDD.n0 VDD.t1 1.31934
R43 VDD.n0 VDD.t0 1.31934
R44 VDD.n1 VDD.t3 1.31934
R45 VDD.n1 VDD.t2 1.31934
R46 VDD.n3 VDD.n2 0.3365
R47 VDD VDD.n3 0.0845
R48 B.n0 B.t4 24.1166
R49 B.n1 B.t5 24.1166
R50 B.n2 B.t6 24.1166
R51 B.n3 B.t7 24.1166
R52 B.n0 B.t0 19.4237
R53 B.n1 B.t1 19.4237
R54 B.n2 B.t2 19.4237
R55 B.n3 B.t3 19.4237
R56 B.n1 B.n0 15.3689
R57 B.n2 B.n1 15.3689
R58 B.n4 B.n3 14.3123
R59 B B.n4 2.84074
R60 B.n4 B.n2 1.05708
R61 A.n0 A.t1 27.2333
R62 A.n0 A.t0 22.8011
R63 A.n1 A.n0 8.06087
R64 A A.n1 0.0378171
R65 A.n1 A 0.0360814
R66 VNW.t8 VNW.t0 558.14
R67 VNW VNW.t8 352.714
R68 VNW.t6 VNW.t7 310.079
R69 VNW.t5 VNW.t6 310.079
R70 VNW.t4 VNW.t5 310.079
R71 VNW.t3 VNW.t4 310.079
R72 VNW.t2 VNW.t3 310.079
R73 VNW.t1 VNW.t2 310.079
R74 VNW.t0 VNW.t1 310.079
R75 VPW.t8 VPW.t0 2127.27
R76 VPW VPW.t8 1344.32
R77 VPW.t6 VPW.t7 1181.82
R78 VPW.t5 VPW.t6 1181.82
R79 VPW.t4 VPW.t5 1181.82
R80 VPW.t3 VPW.t4 1181.82
R81 VPW.t2 VPW.t3 1181.82
R82 VPW.t1 VPW.t2 1181.82
R83 VPW.t0 VPW.t1 1181.82
C0 a_364_440# VNW 0.07678f
C1 VSS Y 0.57773f
C2 VSS A 0.09202f
C3 a_364_440# a_220_68# 0.29214f
C4 VNW VDD 0.23042f
C5 Y B 0.56566f
C6 VSS B 0.08116f
C7 a_220_68# VDD 0.20548f
C8 VNW Y 0.03227f
C9 A VNW 0.10158f
C10 VSS VNW 0.0084f
C11 a_364_440# VDD 1.07368f
C12 a_220_68# Y 0.08637f
C13 a_220_68# A 0.14759f
C14 VNW B 0.34411f
C15 VSS a_220_68# 0.23843f
C16 a_220_68# B 0.04349f
C17 a_364_440# Y 0.48673f
C18 VSS a_364_440# 0.02063f
C19 a_364_440# B 0.06215f
C20 Y VDD 0.00761f
C21 A VDD 0.0929f
C22 VSS VDD 0.01482f
C23 a_220_68# VNW 0.37812f
C24 VDD B 0.03573f
C25 VSS VPW 0.67618f
C26 Y VPW 0.07f
C27 VDD VPW 0.44596f
C28 B VPW 0.59283f
C29 A VPW 0.17345f
C30 VNW VPW 3.15183f
C31 a_364_440# VPW 0.01987f
C32 a_220_68# VPW 0.44104f
C33 VNW.t7 VPW 0.21357f
C34 VNW.t6 VPW 0.09545f
C35 VNW.t5 VPW 0.09545f
C36 VNW.t4 VPW 0.09545f
C37 VNW.t3 VPW 0.09545f
C38 VNW.t2 VPW 0.09545f
C39 VNW.t1 VPW 0.09545f
C40 VNW.t0 VPW 0.13363f
C41 VNW.t8 VPW 0.14019f
C42 A.t1 VPW 0.09981f
C43 A.t0 VPW 0.07258f
C44 A.n0 VPW 0.12744f
C45 A.n1 VPW 0.10884f
C46 B.t6 VPW 0.06699f
C47 B.t2 VPW 0.04688f
C48 B.t5 VPW 0.06699f
C49 B.t1 VPW 0.04688f
C50 B.t4 VPW 0.06699f
C51 B.t0 VPW 0.04688f
C52 B.n0 VPW 0.11361f
C53 B.n1 VPW 0.13799f
C54 B.n2 VPW 0.10167f
C55 B.t7 VPW 0.06699f
C56 B.t3 VPW 0.04688f
C57 B.n3 VPW 0.10996f
C58 B.n4 VPW 0.047f
C59 VDD.t4 VPW 0.10251f
C60 VDD.t1 VPW 0.03802f
C61 VDD.t0 VPW 0.03802f
C62 VDD.n0 VPW 0.07626f
C63 VDD.t3 VPW 0.03802f
C64 VDD.t2 VPW 0.03802f
C65 VDD.n1 VPW 0.10668f
C66 VDD.n2 VPW 0.93286f
C67 VDD.n3 VPW 0.25464f
C68 Y.t3 VPW 0.03873f
C69 Y.t2 VPW 0.03873f
C70 Y.n0 VPW 0.08482f
C71 Y.t5 VPW 0.03873f
C72 Y.t4 VPW 0.03873f
C73 Y.n1 VPW 0.07745f
C74 Y.n2 VPW 0.18379f
C75 Y.t6 VPW 0.03873f
C76 Y.t9 VPW 0.03873f
C77 Y.n3 VPW 0.07745f
C78 Y.n4 VPW 0.10226f
C79 Y.t10 VPW 0.05344f
C80 Y.t11 VPW 0.05344f
C81 Y.n5 VPW 0.1136f
C82 Y.t0 VPW 0.05344f
C83 Y.t8 VPW 0.05344f
C84 Y.n6 VPW 0.10689f
C85 Y.n7 VPW 0.24825f
C86 Y.t7 VPW 0.03873f
C87 Y.t1 VPW 0.03873f
C88 Y.n8 VPW 0.07745f
C89 Y.n9 VPW 0.15345f
C90 VSS.t1 VPW 0.03792f
C91 VSS.t2 VPW 0.03767f
C92 VSS.t4 VPW 0.01415f
C93 VSS.t3 VPW 0.01415f
C94 VSS.n0 VPW 0.02839f
C95 VSS.t8 VPW 0.01415f
C96 VSS.t5 VPW 0.01415f
C97 VSS.n1 VPW 0.02839f
C98 VSS.t0 VPW 0.01415f
C99 VSS.t6 VPW 0.01415f
C100 VSS.n2 VPW 0.02839f
C101 VSS.t7 VPW 0.06139f
C102 VSS.n3 VPW 0.24232f
C103 VSS.n4 VPW 0.11413f
C104 VSS.n5 VPW 0.11413f
C105 VSS.n6 VPW 0.13623f
C106 VSS.n7 VPW 0.10107f
.ends

* NGSPICE file created from gf180mcu_as_sc_mcu7t3v3__nor3_2.ext - technology: gf180mcuD

.subckt gf180mcu_as_sc_mcu7t3v3__nor3_2 VDD VNW VPW VSS A B C Y
X0 a_28_440# A.t2 VDD.t1 VNW.t5 pfet_03v3 ad=0.3588p pd=1.9u as=0.3588p ps=1.9u w=1.38u l=0.28u
X1 Y.t3 A.t1 VSS.t2 VPW.t4 nfet_03v3 ad=0.26p pd=1.52u as=0.44p ps=2.88u w=1u l=0.28u
X2 a_492_440# C.t2 Y.t0 VNW.t1 pfet_03v3 ad=0.621p pd=3.66u as=0.3588p ps=1.9u w=1.38u l=0.28u
X3 VSS.t1 C.t0 Y.t2 VPW.t1 nfet_03v3 ad=0.45p pd=2.9u as=0.26p ps=1.52u w=1u l=0.28u
X4 a_492_440# B.t3 a_28_440# VNW.t2 pfet_03v3 ad=0.3588p pd=1.9u as=0.3588p ps=1.9u w=1.38u l=0.28u
X5 VSS.t3 B.t0 Y.t4 VPW.t3 nfet_03v3 ad=0.58p pd=2.16u as=0.26p ps=1.52u w=1u l=0.28u
X6 a_28_440# B.t2 a_492_440# VNW.t3 pfet_03v3 ad=0.6072p pd=3.64u as=0.3588p ps=1.9u w=1.38u l=0.28u
X7 Y.t5 C.t3 a_492_440# VNW.t0 pfet_03v3 ad=0.3588p pd=1.9u as=0.6072p ps=3.64u w=1.38u l=0.28u
X8 Y.t7 C.t1 VSS.t5 VPW.t0 nfet_03v3 ad=0.26p pd=1.52u as=0.58p ps=2.16u w=1u l=0.28u
X9 Y.t6 B.t1 VSS.t4 VPW.t2 nfet_03v3 ad=0.26p pd=1.52u as=0.26p ps=1.52u w=1u l=0.28u
X10 VDD.t0 A.t3 a_28_440# VNW.t4 pfet_03v3 ad=0.3588p pd=1.9u as=0.6072p ps=3.64u w=1.38u l=0.28u
X11 VSS.t0 A.t0 Y.t1 VPW.t5 nfet_03v3 ad=0.26p pd=1.52u as=0.26p ps=1.52u w=1u l=0.28u
R0 VSS.n5 VSS.n3 6.38659
R1 VSS.n0 VSS.t1 5.22255
R2 VSS.n4 VSS.t2 4.9998
R3 VSS.n1 VSS.t5 3.6545
R4 VSS.n1 VSS.t3 3.6545
R5 VSS.n2 VSS.n1 3.1505
R6 VSS.n3 VSS.t4 1.6385
R7 VSS.n3 VSS.t0 1.6385
R8 VSS.n0 VSS 0.64175
R9 VSS VSS.n6 0.302421
R10 VSS.n5 VSS.n4 0.2405
R11 VSS.n6 VSS.n5 0.22325
R12 VSS.n4 VSS 0.0485
R13 VSS.n2 VSS.n0 0.0390714
R14 VSS.n6 VSS.n2 0.0390714
R15 Y.n2 Y.n1 6.93441
R16 Y.n2 Y.n0 6.31028
R17 Y.n5 Y.n4 6.3005
R18 Y.n5 Y.n3 5.56722
R19 Y.n4 Y.t2 1.6385
R20 Y.n4 Y.t7 1.6385
R21 Y.n1 Y.t1 1.6385
R22 Y.n1 Y.t3 1.6385
R23 Y.n0 Y.t4 1.6385
R24 Y.n0 Y.t6 1.6385
R25 Y.n3 Y.t0 1.31934
R26 Y.n3 Y.t5 1.31934
R27 Y.n5 Y.n2 0.832022
R28 Y Y.n5 0.0313955
R29 VDD VDD.n0 5.45459
R30 VDD.n0 VDD.t1 1.31934
R31 VDD.n0 VDD.t0 1.31934
R32 C.n0 C.t2 29.0701
R33 C.n1 C.t3 26.7237
R34 C.n0 C.t0 24.3773
R35 C.n1 C.t1 22.091
R36 C.n1 C.n0 16.5048
R37 C C.n1 8.04325
R38 B.n0 B.t2 24.3773
R39 B.n1 B.t3 24.3773
R40 B.n0 B.t0 19.0326
R41 B.n1 B.t1 19.0326
R42 B.n2 B.n0 9.57582
R43 B.n2 B.n1 5.59401
R44 B B.n2 4.15011
R45 A.n0 A.t2 23.9862
R46 A.n1 A.t3 23.9862
R47 A.n0 A.t0 19.4237
R48 A.n1 A.t1 19.4237
R49 A.n2 A.n0 11.1875
R50 A A.n2 4.13024
R51 A.n2 A.n1 3.98232
R52 VNW.t3 VNW.t0 558.14
R53 VNW.t0 VNW.t1 310.079
R54 VNW.t2 VNW.t3 310.079
R55 VNW.t5 VNW.t2 310.079
R56 VNW.t4 VNW.t5 310.079
R57 VNW VNW.t4 259.69
R58 VPW.t3 VPW.t0 2127.27
R59 VPW.t0 VPW.t1 1181.82
R60 VPW.t2 VPW.t3 1181.82
R61 VPW.t5 VPW.t2 1181.82
R62 VPW.t4 VPW.t5 1181.82
R63 VPW VPW.t4 989.774
C0 VDD VSS 0.00669f
C1 B a_492_440# 0.06382f
C2 B A 0.07018f
C3 VSS a_492_440# 0.02296f
C4 VSS A 0.07694f
C5 B a_28_440# 0.05093f
C6 B C 0.03429f
C7 Y B 0.2276f
C8 VSS a_28_440# 0.00732f
C9 VSS C 0.04715f
C10 Y VSS 0.51182f
C11 VDD a_492_440# 0.3385f
C12 VDD A 0.03411f
C13 VNW B 0.17603f
C14 VNW VSS 0.00642f
C15 VDD a_28_440# 0.50704f
C16 VDD C 0.01942f
C17 Y VDD 0.00281f
C18 a_28_440# a_492_440# 0.30562f
C19 C a_492_440# 0.08982f
C20 A a_28_440# 0.10754f
C21 C A 0
C22 Y a_492_440# 0.18851f
C23 Y A 0.08644f
C24 VNW VDD 0.14356f
C25 C a_28_440# 0.00245f
C26 Y a_28_440# 0.02272f
C27 Y C 0.26929f
C28 VNW a_492_440# 0.04913f
C29 VNW A 0.17573f
C30 B VSS 0.03628f
C31 VNW a_28_440# 0.02272f
C32 VNW C 0.19253f
C33 VNW Y 0.02554f
C34 VDD B 0.01956f
C35 VSS VPW 0.19941f
C36 Y VPW 0.0543f
C37 VDD VPW 1.15975f
C38 C VPW 0.34102f
C39 B VPW 0.35001f
C40 A VPW 0.33484f
C41 VNW VPW 2.2653f
C42 a_492_440# VPW 0.04187f
C43 a_28_440# VPW 0.01779f
C44 VNW.t1 VPW 0.18382f
C45 VNW.t0 VPW 0.12631f
C46 VNW.t3 VPW 0.12631f
C47 VNW.t2 VPW 0.09022f
C48 VNW.t5 VPW 0.09022f
C49 VNW.t4 VPW 0.08289f
C50 A.t2 VPW 0.06384f
C51 A.t0 VPW 0.04479f
C52 A.n0 VPW 0.0982f
C53 A.t3 VPW 0.06384f
C54 A.t1 VPW 0.04479f
C55 A.n1 VPW 0.09962f
C56 A.n2 VPW 0.04004f
C57 B.t2 VPW 0.07608f
C58 B.t0 VPW 0.05234f
C59 B.n0 VPW 0.11135f
C60 B.t3 VPW 0.07608f
C61 B.t1 VPW 0.05234f
C62 B.n1 VPW 0.12251f
C63 B.n2 VPW 0.04851f
C64 C.t2 VPW 0.08935f
C65 C.t0 VPW 0.065f
C66 C.n0 VPW 0.1077f
C67 C.t3 VPW 0.08658f
C68 C.t1 VPW 0.0625f
C69 C.n1 VPW 0.14215f
C70 VDD.t1 VPW 0.04269f
C71 VDD.t0 VPW 0.04269f
C72 VDD.n0 VPW 0.11092f
C73 Y.t4 VPW 0.04512f
C74 Y.t6 VPW 0.04512f
C75 Y.n0 VPW 0.09026f
C76 Y.t1 VPW 0.04512f
C77 Y.t3 VPW 0.04512f
C78 Y.n1 VPW 0.09822f
C79 Y.n2 VPW 0.24445f
C80 Y.t0 VPW 0.06227f
C81 Y.t5 VPW 0.06227f
C82 Y.n3 VPW 0.13206f
C83 Y.t2 VPW 0.04512f
C84 Y.t7 VPW 0.04512f
C85 Y.n4 VPW 0.09024f
C86 Y.n5 VPW 0.27756f
C87 VSS.t1 VPW 0.03938f
C88 VSS.n0 VPW 0.2911f
C89 VSS.t5 VPW 0.02878f
C90 VSS.t3 VPW 0.02878f
C91 VSS.n1 VPW 0.05755f
C92 VSS.n2 VPW 0.04381f
C93 VSS.t4 VPW 0.0129f
C94 VSS.t0 VPW 0.0129f
C95 VSS.n3 VPW 0.02589f
C96 VSS.t2 VPW 0.03434f
C97 VSS.n4 VPW 0.09056f
C98 VSS.n5 VPW 0.10122f
C99 VSS.n6 VPW 0.23759f
.ends

* NGSPICE file created from gf180mcu_as_sc_mcu7t3v3__oai211_2.ext - technology: gf180mcuD

.subckt gf180mcu_as_sc_mcu7t3v3__oai211_2 VDD VNW VPW VSS A B C Y D
X0 a_28_440# A.t2 VDD.t3 VNW.t7 pfet_03v3 ad=0.3588p pd=1.9u as=0.3588p ps=1.9u w=1.38u l=0.28u
X1 a_796_68# D.t0 Y.t0 VPW.t1 nfet_03v3 ad=0.44p pd=2.88u as=0.26p ps=1.52u w=1u l=0.28u
X2 a_172_68# A.t1 VSS.t2 VPW.t6 nfet_03v3 ad=0.26p pd=1.52u as=0.44p ps=2.88u w=1u l=0.28u
X3 VDD.t2 C.t2 Y.t6 VNW.t3 pfet_03v3 ad=0.3588p pd=1.9u as=0.3588p ps=1.9u w=1.38u l=0.28u
X4 Y.t3 D.t1 a_796_68# VPW.t0 nfet_03v3 ad=0.26p pd=1.52u as=0.26p ps=1.52u w=1u l=0.28u
X5 Y.t5 D.t3 VDD.t1 VNW.t0 pfet_03v3 ad=0.3588p pd=1.9u as=0.3588p ps=1.9u w=1.38u l=0.28u
X6 Y.t2 B.t3 a_28_440# VNW.t4 pfet_03v3 ad=0.3588p pd=1.9u as=0.3588p ps=1.9u w=1.38u l=0.28u
X7 a_796_68# C.t0 a_172_68# VPW.t3 nfet_03v3 ad=0.26p pd=1.52u as=0.26p ps=1.52u w=1u l=0.28u
X8 VSS.t3 B.t0 a_172_68# VPW.t5 nfet_03v3 ad=0.44p pd=2.88u as=0.26p ps=1.52u w=1u l=0.28u
X9 a_28_440# B.t2 Y.t4 VNW.t5 pfet_03v3 ad=0.6072p pd=3.64u as=0.3588p ps=1.9u w=1.38u l=0.28u
X10 Y.t7 C.t3 VDD.t5 VNW.t2 pfet_03v3 ad=0.3588p pd=1.9u as=0.9936p ps=4.2u w=1.38u l=0.28u
X11 a_172_68# B.t1 VSS.t0 VPW.t4 nfet_03v3 ad=0.26p pd=1.52u as=0.26p ps=1.52u w=1u l=0.28u
X12 VDD.t0 D.t2 Y.t1 VNW.t1 pfet_03v3 ad=0.6072p pd=3.64u as=0.3588p ps=1.9u w=1.38u l=0.28u
X13 a_172_68# C.t1 a_796_68# VPW.t2 nfet_03v3 ad=0.26p pd=1.52u as=0.72p ps=3.44u w=1u l=0.28u
X14 VDD.t4 A.t3 a_28_440# VNW.t6 pfet_03v3 ad=0.3588p pd=1.9u as=0.6072p ps=3.64u w=1.38u l=0.28u
X15 VSS.t1 A.t0 a_172_68# VPW.t7 nfet_03v3 ad=0.26p pd=1.52u as=0.26p ps=1.52u w=1u l=0.28u
R0 VSS.n1 VSS.t3 11.2084
R1 VSS.n2 VSS.t2 10.9684
R2 VSS.n1 VSS.n0 6.38659
R3 VSS.n0 VSS.t0 1.6385
R4 VSS.n0 VSS.t1 1.6385
R5 VSS.n2 VSS.n1 0.2405
R6 VSS VSS.n2 0.0485
R7 Y.n6 Y.n5 6.3005
R8 Y.n2 Y.n0 6.18659
R9 Y.n2 Y.n1 5.2005
R10 Y.n4 Y.n3 5.2005
R11 Y.n5 Y.t0 1.6385
R12 Y.n5 Y.t3 1.6385
R13 Y.n3 Y.t1 1.31934
R14 Y.n3 Y.t5 1.31934
R15 Y.n0 Y.t4 1.31934
R16 Y.n0 Y.t2 1.31934
R17 Y.n1 Y.t6 1.31934
R18 Y.n1 Y.t7 1.31934
R19 Y.n4 Y.n2 0.64251
R20 Y.n6 Y.n4 0.397885
R21 Y Y.n6 0.0475769
R22 VDD.n2 VDD.t0 13.6402
R23 VDD.n3 VDD.t5 10.2449
R24 VDD.n4 VDD.n0 5.28659
R25 VDD.n2 VDD.n1 5.28659
R26 VDD.n0 VDD.t3 1.31934
R27 VDD.n0 VDD.t4 1.31934
R28 VDD.n1 VDD.t1 1.31934
R29 VDD.n1 VDD.t2 1.31934
R30 VDD.n4 VDD.n3 0.4985
R31 VDD.n3 VDD.n2 0.2405
R32 VDD VDD.n4 0.1685
R33 D.n1 D.t2 24.1166
R34 D.n0 D.t3 24.1166
R35 D.n1 D.t0 18.9023
R36 D.n0 D.t1 18.9023
R37 D D.n1 15.1675
R38 D.n1 D.n0 14.6005
R39 C.n0 C.t2 23.5951
R40 C.n1 C.t3 23.5951
R41 C.n0 C.t0 19.4237
R42 C.n1 C.t1 19.4237
R43 C.n2 C.n0 7.3005
R44 C.n2 C.n1 7.3005
R45 C C.n2 4.13325
R46 B.n0 B.t2 23.9862
R47 B.n1 B.t3 23.9862
R48 B.n0 B.t0 18.9023
R49 B.n1 B.t1 18.9023
R50 B.n2 B.n1 7.3005
R51 B.n2 B.n0 7.12025
R52 B B.n2 4.10939
R53 A.n0 A.t2 23.5951
R54 A.n1 A.t3 23.5951
R55 A.n0 A.t0 19.2934
R56 A.n1 A.t1 19.2934
R57 A.n2 A.n0 7.3005
R58 A.n2 A.n1 7.12025
R59 A A.n2 4.1105
R60 VNW.t5 VNW.t2 666.668
R61 VNW.t0 VNW.t1 310.079
R62 VNW.t3 VNW.t0 310.079
R63 VNW.t2 VNW.t3 310.079
R64 VNW.t4 VNW.t5 310.079
R65 VNW.t7 VNW.t4 310.079
R66 VNW.t6 VNW.t7 310.079
R67 VNW VNW.t6 259.69
R68 VPW.t5 VPW.t2 2540.91
R69 VPW.t0 VPW.t1 1181.82
R70 VPW.t3 VPW.t0 1181.82
R71 VPW.t2 VPW.t3 1181.82
R72 VPW.t4 VPW.t5 1181.82
R73 VPW.t7 VPW.t4 1181.82
R74 VPW.t6 VPW.t7 1181.82
R75 VPW VPW.t6 989.774
C0 B VNW 0.16696f
C1 B Y 0.05913f
C2 VDD C 0.03877f
C3 VDD VSS 0.00605f
C4 VDD a_28_440# 0.64118f
C5 VNW C 0.17784f
C6 VNW VSS 0.00547f
C7 a_796_68# D 0.06414f
C8 VNW a_28_440# 0.02522f
C9 C Y 0.1922f
C10 VSS Y 0.0028f
C11 a_28_440# Y 0.29811f
C12 a_172_68# A 0.08923f
C13 a_796_68# A 0
C14 B D 0
C15 a_172_68# a_796_68# 0.33551f
C16 B A 0.05837f
C17 C D 0.03527f
C18 VNW VDD 0.21983f
C19 D VSS 0.02861f
C20 B a_172_68# 0.13813f
C21 B a_796_68# 0
C22 D a_28_440# 0
C23 VDD Y 0.32233f
C24 A C 0
C25 VNW Y 0.05854f
C26 A VSS 0.04523f
C27 A a_28_440# 0.08936f
C28 a_172_68# C 0.01247f
C29 a_172_68# VSS 0.70443f
C30 a_796_68# C 0.17201f
C31 a_796_68# VSS 0.47404f
C32 a_172_68# a_28_440# 0.02154f
C33 VDD D 0.0659f
C34 B C 0.0238f
C35 B VSS 0.03269f
C36 B a_28_440# 0.03493f
C37 VNW D 0.1999f
C38 A VDD 0.03354f
C39 D Y 0.11794f
C40 a_172_68# VDD 0.00154f
C41 C VSS 0.02212f
C42 a_796_68# VDD 0.01f
C43 C a_28_440# 0.00293f
C44 a_28_440# VSS 0.01269f
C45 VNW A 0.1644f
C46 A Y 0
C47 VNW a_172_68# 0.0092f
C48 VNW a_796_68# 0.00484f
C49 a_172_68# Y 0.02978f
C50 a_796_68# Y 0.14399f
C51 B VDD 0.01994f
C52 VSS VPW 0.57396f
C53 Y VPW 0.06606f
C54 VDD VPW 0.4306f
C55 D VPW 0.3446f
C56 C VPW 0.2937f
C57 B VPW 0.29318f
C58 A VPW 0.30796f
C59 VNW VPW 2.95775f
C60 a_796_68# VPW 0.0262f
C61 a_172_68# VPW 0.02981f
C62 a_28_440# VPW 0.01968f
C63 VNW.t1 VPW 0.22182f
C64 VNW.t0 VPW 0.08918f
C65 VNW.t3 VPW 0.08918f
C66 VNW.t2 VPW 0.14045f
C67 VNW.t5 VPW 0.14045f
C68 VNW.t4 VPW 0.08918f
C69 VNW.t7 VPW 0.08918f
C70 VNW.t6 VPW 0.08193f
C71 A.t2 VPW 0.05737f
C72 A.t0 VPW 0.04043f
C73 A.n0 VPW 0.08196f
C74 A.t3 VPW 0.05737f
C75 A.t1 VPW 0.04043f
C76 A.n1 VPW 0.08151f
C77 A.n2 VPW 0.03771f
C78 B.t2 VPW 0.0642f
C79 B.t0 VPW 0.04436f
C80 B.n0 VPW 0.09048f
C81 B.t3 VPW 0.0642f
C82 B.t1 VPW 0.04436f
C83 B.n1 VPW 0.09098f
C84 B.n2 VPW 0.04184f
C85 C.t2 VPW 0.08491f
C86 C.t0 VPW 0.06006f
C87 C.n0 VPW 0.12065f
C88 C.t3 VPW 0.08491f
C89 C.t1 VPW 0.06006f
C90 C.n1 VPW 0.12065f
C91 C.n2 VPW 0.05562f
C92 D.t2 VPW 0.05963f
C93 D.t0 VPW 0.04109f
C94 D.t3 VPW 0.05963f
C95 D.t1 VPW 0.04109f
C96 D.n0 VPW 0.10209f
C97 D.n1 VPW 0.12572f
C98 VDD.t3 VPW 0.02891f
C99 VDD.t4 VPW 0.02891f
C100 VDD.n0 VPW 0.05798f
C101 VDD.t5 VPW 0.13576f
C102 VDD.t1 VPW 0.02891f
C103 VDD.t2 VPW 0.02891f
C104 VDD.n1 VPW 0.05798f
C105 VDD.t0 VPW 0.08247f
C106 VDD.n2 VPW 0.34961f
C107 VDD.n3 VPW 0.27662f
C108 VDD.n4 VPW 0.22891f
C109 Y.t4 VPW 0.0515f
C110 Y.t2 VPW 0.0515f
C111 Y.n0 VPW 0.11831f
C112 Y.t6 VPW 0.0515f
C113 Y.t7 VPW 0.0515f
C114 Y.n1 VPW 0.10299f
C115 Y.n2 VPW 0.2196f
C116 Y.t1 VPW 0.0515f
C117 Y.t5 VPW 0.0515f
C118 Y.n3 VPW 0.10299f
C119 Y.n4 VPW 0.14056f
C120 Y.t0 VPW 0.03732f
C121 Y.t3 VPW 0.03732f
C122 Y.n5 VPW 0.07463f
C123 Y.n6 VPW 0.07486f
C124 VSS.t2 VPW 0.07517f
C125 VSS.t0 VPW 0.02585f
C126 VSS.t1 VPW 0.02585f
C127 VSS.n0 VPW 0.05187f
C128 VSS.t3 VPW 0.09033f
C129 VSS.n1 VPW 0.90126f
C130 VSS.n2 VPW 0.1447f
.ends

* NGSPICE file created from gf180mcu_as_sc_mcu7t3v3__or2_2.ext - technology: gf180mcuD

.subckt gf180mcu_as_sc_mcu7t3v3__or2_2 VDD VNW VPW VSS B A Y
X0 VDD.t0 B.t1 a_172_440# VNW.t0 pfet_03v3 ad=0.3588p pd=1.9u as=0.3588p ps=1.9u w=1.38u l=0.28u
X1 a_28_440# A.t0 VSS.t1 VPW.t3 nfet_03v3 ad=0.26p pd=1.52u as=0.44p ps=2.88u w=1u l=0.28u
X2 Y.t3 a_28_440# VDD.t1 VNW.t1 pfet_03v3 ad=0.3588p pd=1.9u as=0.3588p ps=1.9u w=1.38u l=0.28u
X3 VSS.t2 a_28_440# Y.t1 VPW.t2 nfet_03v3 ad=0.52p pd=3.04u as=0.26p ps=1.52u w=1u l=0.28u
X4 VDD.t2 a_28_440# Y.t2 VNW.t2 pfet_03v3 ad=0.7176p pd=3.8u as=0.3588p ps=1.9u w=1.38u l=0.28u
X5 Y.t0 a_28_440# VSS.t3 VPW.t1 nfet_03v3 ad=0.26p pd=1.52u as=0.26p ps=1.52u w=1u l=0.28u
X6 a_172_440# A.t1 a_28_440# VNW.t3 pfet_03v3 ad=0.3588p pd=1.9u as=0.6072p ps=3.64u w=1.38u l=0.28u
X7 VSS.t0 B.t0 a_28_440# VPW.t0 nfet_03v3 ad=0.26p pd=1.52u as=0.26p ps=1.52u w=1u l=0.28u
R0 VSS.n2 VSS.t1 10.9684
R1 VSS.n1 VSS.n0 6.38659
R2 VSS.n1 VSS.t2 5.2398
R3 VSS.n0 VSS.t3 1.6385
R4 VSS.n0 VSS.t0 1.6385
R5 VSS.n2 VSS.n1 0.2405
R6 VSS VSS.n2 0.0485
R7 Y.n2 Y.n1 6.3005
R8 Y.n2 Y.n0 2.94794
R9 Y.n1 Y.t1 1.6385
R10 Y.n1 Y.t0 1.6385
R11 Y.n0 Y.t2 1.31934
R12 Y.n0 Y.t3 1.31934
R13 Y Y.n2 0.0465465
R14 VDD.n1 VDD.n0 5.28659
R15 VDD.n1 VDD.t2 3.57833
R16 VDD.n0 VDD.t1 1.31934
R17 VDD.n0 VDD.t0 1.31934
R18 VDD VDD.n1 0.2885
R19 B.n0 B.t1 27.5107
R20 B.n0 B.t0 22.5169
R21 B B.n0 8.02014
R22 A.n0 A.t1 27.2902
R23 A.n0 A.t0 22.7374
R24 A A.n0 8.09156
R25 VNW.t1 VNW.t2 310.079
R26 VNW.t0 VNW.t1 310.079
R27 VNW.t3 VNW.t0 310.079
R28 VNW VNW.t3 259.69
R29 VPW.t1 VPW.t2 1181.82
R30 VPW.t0 VPW.t1 1181.82
R31 VPW.t3 VPW.t0 1181.82
R32 VPW VPW.t3 989.774
C0 VSS VNW 0.00569f
C1 A VSS 0.04863f
C2 a_172_440# VSS 0
C3 VSS VDD 0.03363f
C4 VSS Y 0.11262f
C5 VSS a_28_440# 0.19768f
C6 VNW B 0.07769f
C7 A B 0.08818f
C8 a_172_440# B 0.004f
C9 B VDD 0.01529f
C10 B Y 0
C11 B a_28_440# 0.43494f
C12 A VNW 0.08339f
C13 VNW VDD 0.12155f
C14 VNW Y 0.02198f
C15 VNW a_28_440# 0.19329f
C16 A VDD 0.01241f
C17 a_172_440# VDD 0.00745f
C18 A Y 0
C19 a_172_440# Y 0.00111f
C20 VDD Y 0.27964f
C21 A a_28_440# 0.06067f
C22 a_172_440# a_28_440# 0.01711f
C23 VDD a_28_440# 0.24574f
C24 VSS B 0.01596f
C25 Y a_28_440# 0.26697f
C26 VSS VPW 0.34909f
C27 Y VPW 0.04197f
C28 VDD VPW 0.3386f
C29 B VPW 0.30176f
C30 A VPW 0.2013f
C31 VNW VPW 1.56575f
C32 a_28_440# VPW 0.2656f
C33 VNW.t2 VPW 0.17173f
C34 VNW.t1 VPW 0.08428f
C35 VNW.t0 VPW 0.08428f
C36 VNW.t3 VPW 0.07744f
C37 A.t1 VPW 0.07401f
C38 A.t0 VPW 0.05386f
C39 A.n0 VPW 0.0931f
C40 B.t1 VPW 0.14552f
C41 B.t0 VPW 0.10472f
C42 B.n0 VPW 0.18151f
C43 VDD.t1 VPW 0.03046f
C44 VDD.t0 VPW 0.03046f
C45 VDD.n0 VPW 0.0611f
C46 VDD.t2 VPW 0.10366f
C47 VDD.n1 VPW 0.39222f
C48 Y.t2 VPW 0.05333f
C49 Y.t3 VPW 0.05333f
C50 Y.n0 VPW 0.12806f
C51 Y.t1 VPW 0.03864f
C52 Y.t0 VPW 0.03864f
C53 Y.n1 VPW 0.07729f
C54 Y.n2 VPW 0.28027f
C55 VSS.t1 VPW 0.03664f
C56 VSS.t3 VPW 0.0126f
C57 VSS.t0 VPW 0.0126f
C58 VSS.n0 VPW 0.02529f
C59 VSS.t2 VPW 0.04375f
C60 VSS.n1 VPW 0.20376f
C61 VSS.n2 VPW 0.07054f
.ends

* NGSPICE file created from gf180mcu_as_sc_mcu7t3v3__or2_4.ext - technology: gf180mcuD

.subckt gf180mcu_as_sc_mcu7t3v3__or2_4 VDD VNW VPW VSS B A Y
X0 VSS.t2 a_28_440# Y.t6 VPW.t4 nfet_03v3 ad=0.6p pd=3.2u as=0.26p ps=1.52u w=1u l=0.28u
X1 VDD.t4 B.t1 a_172_440# VNW.t0 pfet_03v3 ad=0.3588p pd=1.9u as=0.3588p ps=1.9u w=1.38u l=0.28u
X2 Y.t2 a_28_440# VDD.t2 VNW.t3 pfet_03v3 ad=0.3588p pd=1.9u as=0.3588p ps=1.9u w=1.38u l=0.28u
X3 a_28_440# A.t0 VSS.t0 VPW.t5 nfet_03v3 ad=0.26p pd=1.52u as=0.44p ps=2.88u w=1u l=0.28u
X4 Y.t5 a_28_440# VSS.t3 VPW.t3 nfet_03v3 ad=0.26p pd=1.52u as=0.26p ps=1.52u w=1u l=0.28u
X5 Y.t0 a_28_440# VDD.t0 VNW.t1 pfet_03v3 ad=0.3588p pd=1.9u as=0.3588p ps=1.9u w=1.38u l=0.28u
X6 VDD.t3 a_28_440# Y.t7 VNW.t4 pfet_03v3 ad=0.828p pd=3.96u as=0.3588p ps=1.9u w=1.38u l=0.28u
X7 VSS.t4 a_28_440# Y.t4 VPW.t2 nfet_03v3 ad=0.26p pd=1.52u as=0.26p ps=1.52u w=1u l=0.28u
X8 VDD.t1 a_28_440# Y.t1 VNW.t2 pfet_03v3 ad=0.3588p pd=1.9u as=0.3588p ps=1.9u w=1.38u l=0.28u
X9 Y.t3 a_28_440# VSS.t1 VPW.t1 nfet_03v3 ad=0.26p pd=1.52u as=0.26p ps=1.52u w=1u l=0.28u
X10 a_172_440# A.t1 a_28_440# VNW.t5 pfet_03v3 ad=0.3588p pd=1.9u as=0.6072p ps=3.64u w=1.38u l=0.28u
X11 VSS.t5 B.t0 a_28_440# VPW.t0 nfet_03v3 ad=0.26p pd=1.52u as=0.26p ps=1.52u w=1u l=0.28u
R0 VSS.n4 VSS.t0 10.9684
R1 VSS.n3 VSS.n0 6.38659
R2 VSS.n2 VSS.t2 5.2398
R3 VSS.n2 VSS.n1 3.3618
R4 VSS.n1 VSS.t3 1.6385
R5 VSS.n1 VSS.t4 1.6385
R6 VSS.n0 VSS.t1 1.6385
R7 VSS.n0 VSS.t5 1.6385
R8 VSS.n3 VSS.n2 0.2405
R9 VSS.n4 VSS.n3 0.2405
R10 VSS VSS.n4 0.0485
R11 Y.n2 Y.n1 6.50202
R12 Y.n6 Y.n5 6.3005
R13 Y.n2 Y.n0 2.95854
R14 Y.n4 Y.n3 2.83518
R15 Y.n5 Y.t6 1.6385
R16 Y.n5 Y.t5 1.6385
R17 Y.n1 Y.t4 1.6385
R18 Y.n1 Y.t3 1.6385
R19 Y.n3 Y.t7 1.31934
R20 Y.n3 Y.t2 1.31934
R21 Y.n0 Y.t1 1.31934
R22 Y.n0 Y.t0 1.31934
R23 Y.n4 Y.n2 0.581587
R24 Y.n6 Y.n4 0.155437
R25 Y Y.n6 0.0392342
R26 VDD.n3 VDD.n0 5.28659
R27 VDD.n2 VDD.t3 3.58028
R28 VDD.n2 VDD.n1 2.01949
R29 VDD.n0 VDD.t0 1.31934
R30 VDD.n0 VDD.t4 1.31934
R31 VDD.n1 VDD.t2 1.31934
R32 VDD.n1 VDD.t1 1.31934
R33 VDD VDD.n3 0.2885
R34 VDD.n3 VDD.n2 0.2405
R35 B.n0 B.t1 27.5107
R36 B.n0 B.t0 22.5169
R37 B B.n0 8.02014
R38 A.n0 A.t1 27.2902
R39 A.n0 A.t0 22.7374
R40 A A.n0 8.09156
R41 VNW.t3 VNW.t4 310.079
R42 VNW.t2 VNW.t3 310.079
R43 VNW.t1 VNW.t2 310.079
R44 VNW.t0 VNW.t1 310.079
R45 VNW.t5 VNW.t0 310.079
R46 VNW VNW.t5 259.69
R47 VPW.t3 VPW.t4 1181.82
R48 VPW.t2 VPW.t3 1181.82
R49 VPW.t1 VPW.t2 1181.82
R50 VPW.t0 VPW.t1 1181.82
R51 VPW.t5 VPW.t0 1181.82
R52 VPW VPW.t5 989.774
C0 a_28_440# VSS 0.25332f
C1 Y a_172_440# 0.00111f
C2 VSS VNW 0.00595f
C3 Y a_28_440# 0.3629f
C4 B VSS 0.01596f
C5 a_28_440# a_172_440# 0.01711f
C6 A VSS 0.04863f
C7 VDD VSS 0.03542f
C8 Y VNW 0.05182f
C9 Y B 0
C10 Y A 0
C11 Y VDD 0.59663f
C12 B a_172_440# 0.004f
C13 VDD a_172_440# 0.00745f
C14 a_28_440# VNW 0.36902f
C15 a_28_440# B 0.43494f
C16 a_28_440# A 0.06067f
C17 a_28_440# VDD 0.30628f
C18 B VNW 0.07769f
C19 A VNW 0.08339f
C20 Y VSS 0.30561f
C21 VDD VNW 0.18049f
C22 A B 0.08818f
C23 VSS a_172_440# 0
C24 B VDD 0.01529f
C25 A VDD 0.01241f
C26 VSS VPW 0.44646f
C27 Y VPW 0.04943f
C28 VDD VPW 0.4067f
C29 B VPW 0.30176f
C30 A VPW 0.2013f
C31 VNW VPW 2.09696f
C32 a_28_440# VPW 0.47737f
C33 VNW.t4 VPW 0.20339f
C34 VNW.t3 VPW 0.09515f
C35 VNW.t2 VPW 0.09515f
C36 VNW.t1 VPW 0.09515f
C37 VNW.t0 VPW 0.09515f
C38 VNW.t5 VPW 0.08742f
C39 A.t1 VPW 0.07401f
C40 A.t0 VPW 0.05386f
C41 A.n0 VPW 0.0931f
C42 B.t1 VPW 0.14552f
C43 B.t0 VPW 0.10472f
C44 B.n0 VPW 0.18151f
C45 VDD.t0 VPW 0.0324f
C46 VDD.t4 VPW 0.0324f
C47 VDD.n0 VPW 0.06499f
C48 VDD.t2 VPW 0.0324f
C49 VDD.t1 VPW 0.0324f
C50 VDD.n1 VPW 0.0713f
C51 VDD.t3 VPW 0.12346f
C52 VDD.n2 VPW 0.45383f
C53 VDD.n3 VPW 0.20674f
C54 Y.t1 VPW 0.05461f
C55 Y.t0 VPW 0.05461f
C56 Y.n0 VPW 0.1181f
C57 Y.t4 VPW 0.03957f
C58 Y.t3 VPW 0.03957f
C59 Y.n1 VPW 0.08019f
C60 Y.n2 VPW 0.20696f
C61 Y.t7 VPW 0.05461f
C62 Y.t2 VPW 0.05461f
C63 Y.n3 VPW 0.12023f
C64 Y.n4 VPW 0.27667f
C65 Y.t6 VPW 0.03957f
C66 Y.t5 VPW 0.03957f
C67 Y.n5 VPW 0.07915f
C68 Y.n6 VPW 0.0511f
C69 VSS.t0 VPW 0.04097f
C70 VSS.t1 VPW 0.01409f
C71 VSS.t5 VPW 0.01409f
C72 VSS.n0 VPW 0.02828f
C73 VSS.t3 VPW 0.01409f
C74 VSS.t4 VPW 0.01409f
C75 VSS.n1 VPW 0.02952f
C76 VSS.t2 VPW 0.05506f
C77 VSS.n2 VPW 0.25202f
C78 VSS.n3 VPW 0.11368f
C79 VSS.n4 VPW 0.07887f
.ends

* NGSPICE file created from gf180mcu_as_sc_mcu7t3v3__tap_2.ext - technology: gf180mcuD

.subckt gf180mcu_as_sc_mcu7t3v3__tap_2 VDD VSS
C0 VDD VSS 0.81429f
.ends

* NGSPICE file created from gf180mcu_as_sc_mcu7t3v3__tieh_4.ext - technology: gf180mcuD

.subckt gf180mcu_as_sc_mcu7t3v3__tieh_4 VDD VNW VPW VSS ONE
X0 a_112_319# a_112_319# VSS.t0 VPW.t0 nfet_03v3 ad=0.44p pd=2.88u as=0.44p ps=2.88u w=1u l=0.28u
X1 ONE.t0 a_112_319# VDD.t0 VNW.t0 pfet_03v3 ad=0.6072p pd=3.64u as=0.6072p ps=3.64u w=1.38u l=0.28u
R0 VSS VSS.t0 5.02391
R1 ONE ONE.t0 4.07184
R2 VDD VDD.t0 3.38437
R3 VNW VNW.t0 251.613
R4 VPW VPW.t0 1142.74
C0 VNW a_112_319# 0.09247f
C1 ONE a_112_319# 0.05062f
C2 VDD a_112_319# 0.03774f
C3 VNW ONE 0.03312f
C4 VNW VDD 0.09975f
C5 VDD ONE 0.18246f
C6 VSS a_112_319# 0.16367f
C7 VNW VSS 0.01215f
C8 ONE VSS 0.00286f
C9 VDD VSS 0.02909f
C10 VSS VPW 0.41665f
C11 ONE VPW 0.17425f
C12 VDD VPW 0.45388f
C13 VNW VPW 1.05825f
C14 a_112_319# VPW 0.19998f
C15 VNW.t0 VPW 0.139f
C16 VDD.t0 VPW 0.07412f
C17 ONE.t0 VPW 0.12445f
C18 VSS.t0 VPW 0.03592f
.ends

* NGSPICE file created from gf180mcu_as_sc_mcu7t3v3__tiel_4.ext - technology: gf180mcuD

.subckt gf180mcu_as_sc_mcu7t3v3__tiel_4 VDD VNW VPW VSS ZERO
X0 ZERO.t0 a_112_319# VSS.t0 VPW.t0 nfet_03v3 ad=0.44p pd=2.88u as=0.44p ps=2.88u w=1u l=0.28u
X1 a_112_319# a_112_319# VDD.t0 VNW.t0 pfet_03v3 ad=0.6072p pd=3.64u as=0.6072p ps=3.64u w=1.38u l=0.28u
R0 ZERO ZERO.t0 4.886
R1 VSS VSS.t0 5.02391
R2 VDD VDD.t0 3.38437
R3 VNW VNW.t0 251.613
R4 VPW VPW.t0 1142.74
C0 VNW a_112_319# 0.13263f
C1 VSS a_112_319# 0.03486f
C2 VDD a_112_319# 0.19197f
C3 VNW VSS 0.01244f
C4 VNW VDD 0.10109f
C5 VDD VSS 0.03014f
C6 ZERO a_112_319# 0.07812f
C7 VNW ZERO 0
C8 VSS ZERO 0.1659f
C9 VDD ZERO 0
C10 ZERO VPW 0.17481f
C11 VSS VPW 0.44559f
C12 VDD VPW 0.43486f
C13 VNW VPW 1.06196f
C14 a_112_319# VPW 0.18423f
C15 VNW.t0 VPW 0.14423f
C16 VDD.t0 VPW 0.06884f
C17 VSS.t0 VPW 0.04206f
C18 ZERO.t0 VPW 0.10974f
.ends

* NGSPICE file created from gf180mcu_as_sc_mcu7t3v3__xnor2_2.ext - technology: gf180mcuD

.subckt gf180mcu_as_sc_mcu7t3v3__xnor2_2 VDD VNW VPW VSS B A Y
X0 VSS.t3 a_556_68# Y.t2 VPW.t4 nfet_03v3 ad=0.85p pd=3.7u as=0.285p ps=1.57u w=1u l=0.28u
X1 VDD.t4 a_556_68# Y.t0 VNW.t4 pfet_03v3 ad=1.173p pd=4.46u as=0.3933p ps=1.95u w=1.38u l=0.28u
X2 Y.t1 a_556_68# VSS.t4 VPW.t3 nfet_03v3 ad=0.285p pd=1.57u as=0.26p ps=1.52u w=1u l=0.28u
X3 a_332_440# A.t2 VDD.t0 VNW.t6 pfet_03v3 ad=0.5796p pd=2.22u as=0.3588p ps=1.9u w=1.38u l=0.28u
X4 VSS.t1 A.t1 a_28_68# VPW.t5 nfet_03v3 ad=0.54p pd=2.08u as=0.44p ps=2.88u w=1u l=0.28u
X5 a_556_68# a_500_24# a_444_68# VPW.t0 nfet_03v3 ad=0.62p pd=2.24u as=0.14p ps=1.28u w=1u l=0.28u
X6 a_500_24# A.t0 a_556_68# VPW.t6 nfet_03v3 ad=0.31p pd=1.62u as=0.62p ps=2.24u w=1u l=0.28u
X7 a_500_24# a_28_68# a_556_68# VNW.t2 pfet_03v3 ad=0.7866p pd=2.52u as=0.4968p ps=2.1u w=1.38u l=0.28u
X8 VDD.t2 B.t1 a_500_24# VNW.t1 pfet_03v3 ad=0.3588p pd=1.9u as=0.7866p ps=2.52u w=1.38u l=0.28u
X9 VSS.t0 B.t0 a_500_24# VPW.t1 nfet_03v3 ad=0.26p pd=1.52u as=0.31p ps=1.62u w=1u l=0.28u
X10 a_444_68# a_28_68# VSS.t2 VPW.t2 nfet_03v3 ad=0.14p pd=1.28u as=0.54p ps=2.08u w=1u l=0.28u
X11 Y.t3 a_556_68# VDD.t3 VNW.t3 pfet_03v3 ad=0.3933p pd=1.95u as=0.3588p ps=1.9u w=1.38u l=0.28u
X12 VDD.t1 A.t3 a_28_68# VNW.t5 pfet_03v3 ad=0.3588p pd=1.9u as=0.6072p ps=3.64u w=1.38u l=0.28u
X13 a_556_68# a_500_24# a_332_440# VNW.t0 pfet_03v3 ad=0.4968p pd=2.1u as=0.5796p ps=2.22u w=1.38u l=0.28u
R0 VSS.n2 VSS.n1 6.38659
R1 VSS.n3 VSS.n0 6.38659
R2 VSS.n2 VSS.t3 5.2473
R3 VSS.n0 VSS.t2 5.1665
R4 VSS.n1 VSS.t4 1.6385
R5 VSS.n1 VSS.t0 1.6385
R6 VSS.n0 VSS.t1 1.6385
R7 VSS.n3 VSS.n2 0.6515
R8 VSS VSS.n3 0.1685
R9 Y.n2 Y.n1 6.3005
R10 Y.n2 Y.n0 3.01627
R11 Y.n1 Y.t1 1.9535
R12 Y.n1 Y.t2 1.6385
R13 Y.n0 Y.t3 1.57296
R14 Y.n0 Y.t0 1.31934
R15 Y Y.n2 0.0435986
R16 VDD.n3 VDD.n0 5.28659
R17 VDD.n2 VDD.n1 5.28659
R18 VDD.n2 VDD.t4 3.58583
R19 VDD.n0 VDD.t0 1.31934
R20 VDD.n0 VDD.t1 1.31934
R21 VDD.n1 VDD.t3 1.31934
R22 VDD.n1 VDD.t2 1.31934
R23 VDD.n3 VDD.n2 0.6515
R24 VDD VDD.n3 0.1685
R25 B.n0 B.t1 27.7048
R26 B.n0 B.t0 23.2727
R27 B B.n0 8.03774
R28 A.n2 A.t0 41.8235
R29 A.n0 A.t2 36.9256
R30 A.n0 A.t3 22.8061
R31 A.n1 A.t1 22.7513
R32 A.n2 A.n1 8.0005
R33 A.n1 A.n0 4.32287
R34 A A.n2 0.0413
R35 VNW.t2 VNW.t1 550.389
R36 VNW.t6 VNW.t0 434.11
R37 VNW.t0 VNW.t2 387.598
R38 VNW.t3 VNW.t4 329.457
R39 VNW.t1 VNW.t3 310.079
R40 VNW.t5 VNW.t6 310.079
R41 VNW VNW.t5 259.69
R42 VPW.t0 VPW.t6 2245.45
R43 VPW.t5 VPW.t2 2009.09
R44 VPW.t6 VPW.t1 1329.55
R45 VPW.t3 VPW.t4 1255.68
R46 VPW.t1 VPW.t3 1181.82
R47 VPW VPW.t5 989.774
R48 VPW.t2 VPW.t0 827.274
C0 Y B 0.00307f
C1 A a_28_68# 0.77778f
C2 Y VSS 0.08185f
C3 VSS B 0.03696f
C4 Y VDD 0.231f
C5 Y a_556_68# 0.36511f
C6 B VDD 0.01704f
C7 B a_556_68# 0.16936f
C8 VSS VDD 0.04171f
C9 VSS a_556_68# 0.13604f
C10 VNW a_28_68# 0.16217f
C11 VDD a_556_68# 0.36f
C12 VSS a_444_68# 0.0055f
C13 Y a_332_440# 0
C14 a_500_24# a_28_68# 0.27998f
C15 a_444_68# VDD 0
C16 a_332_440# VSS 0.00158f
C17 a_444_68# a_556_68# 0.00253f
C18 a_332_440# VDD 0.0172f
C19 a_332_440# a_556_68# 0.009f
C20 VNW A 0.21169f
C21 A a_500_24# 0.29731f
C22 Y a_28_68# 0.00573f
C23 B a_28_68# 0.00835f
C24 VSS a_28_68# 0.17301f
C25 a_28_68# VDD 0.19263f
C26 a_28_68# a_556_68# 0.28582f
C27 VNW a_500_24# 0.11241f
C28 Y A 0.00159f
C29 A B 0.01877f
C30 a_444_68# a_28_68# 0.00114f
C31 VSS A 0.1209f
C32 a_332_440# a_28_68# 0.01662f
C33 A VDD 0.12048f
C34 A a_556_68# 0.22454f
C35 VNW Y 0.02065f
C36 VNW B 0.07821f
C37 a_444_68# A 0.00363f
C38 VNW VSS 0.00991f
C39 a_332_440# A 0.02207f
C40 Y a_500_24# 0.02147f
C41 VNW VDD 0.21598f
C42 a_500_24# B 0.10446f
C43 VNW a_556_68# 0.18313f
C44 VSS a_500_24# 0.05439f
C45 a_500_24# VDD 0.03306f
C46 a_500_24# a_556_68# 0.8026f
C47 VSS VPW 0.5823f
C48 Y VPW 0.03757f
C49 VDD VPW 0.43474f
C50 B VPW 0.16472f
C51 A VPW 0.37459f
C52 VNW VPW 2.78665f
C53 a_556_68# VPW 0.22231f
C54 a_28_68# VPW 0.36972f
C55 a_500_24# VPW 0.1172f
C56 VNW.t4 VPW 0.22683f
C57 VNW.t3 VPW 0.09427f
C58 VNW.t1 VPW 0.12684f
C59 VNW.t2 VPW 0.13827f
C60 VNW.t0 VPW 0.12113f
C61 VNW.t6 VPW 0.1097f
C62 VNW.t5 VPW 0.08399f
C63 A.t0 VPW 0.24968f
C64 A.t2 VPW 0.15555f
C65 A.t3 VPW 0.11909f
C66 A.n0 VPW 0.17041f
C67 A.t1 VPW 0.09477f
C68 A.n1 VPW 0.0905f
C69 A.n2 VPW 0.9039f
C70 B.t1 VPW 0.12336f
C71 B.t0 VPW 0.08988f
C72 B.n0 VPW 0.14534f
C73 VDD.t0 VPW 0.0282f
C74 VDD.t1 VPW 0.0282f
C75 VDD.n0 VPW 0.05657f
C76 VDD.t3 VPW 0.0282f
C77 VDD.t2 VPW 0.0282f
C78 VDD.n1 VPW 0.05657f
C79 VDD.t4 VPW 0.14379f
C80 VDD.n2 VPW 0.53598f
C81 VDD.n3 VPW 0.27145f
C82 Y.t0 VPW 0.05937f
C83 Y.t3 VPW 0.07079f
C84 Y.n0 VPW 0.153f
C85 Y.t2 VPW 0.04302f
C86 Y.t1 VPW 0.0513f
C87 Y.n1 VPW 0.09432f
C88 Y.n2 VPW 0.24915f
C89 VSS.t2 VPW 0.0358f
C90 VSS.t1 VPW 0.01135f
C91 VSS.n0 VPW 0.04722f
C92 VSS.t4 VPW 0.01135f
C93 VSS.t0 VPW 0.01135f
C94 VSS.n1 VPW 0.02278f
C95 VSS.t3 VPW 0.0601f
C96 VSS.n2 VPW 0.28181f
C97 VSS.n3 VPW 0.15077f
.ends

* NGSPICE file created from gf180mcu_as_sc_mcu7t3v3__xnor2_4.ext - technology: gf180mcuD

.subckt gf180mcu_as_sc_mcu7t3v3__xnor2_4 VDD VNW VPW VSS B A Y
X0 VSS.t5 a_556_68# Y.t4 VPW.t3 nfet_03v3 ad=0.26p pd=1.52u as=0.285p ps=1.57u w=1u l=0.28u
X1 VDD.t1 a_556_68# Y.t7 VNW.t3 pfet_03v3 ad=0.3588p pd=1.9u as=0.3933p ps=1.95u w=1.38u l=0.28u
X2 Y.t3 a_556_68# VSS.t4 VPW.t2 nfet_03v3 ad=0.285p pd=1.57u as=0.26p ps=1.52u w=1u l=0.28u
X3 a_332_440# A.t2 VDD.t4 VNW.t8 pfet_03v3 ad=0.5796p pd=2.22u as=0.3588p ps=1.9u w=1.38u l=0.28u
X4 VSS.t6 A.t1 a_28_68# VPW.t7 nfet_03v3 ad=0.54p pd=2.08u as=0.44p ps=2.88u w=1u l=0.28u
X5 a_556_68# a_500_24# a_444_68# VPW.t6 nfet_03v3 ad=0.62p pd=2.24u as=0.14p ps=1.28u w=1u l=0.28u
X6 Y.t0 a_556_68# VDD.t2 VNW.t4 pfet_03v3 ad=0.3588p pd=1.9u as=0.3588p ps=1.9u w=1.38u l=0.28u
X7 a_500_24# A.t0 a_556_68# VPW.t8 nfet_03v3 ad=0.31p pd=1.62u as=0.62p ps=2.24u w=1u l=0.28u
X8 a_500_24# a_28_68# a_556_68# VNW.t0 pfet_03v3 ad=0.7866p pd=2.52u as=0.4968p ps=2.1u w=1.38u l=0.28u
X9 VDD.t6 B.t1 a_500_24# VNW.t1 pfet_03v3 ad=0.3588p pd=1.9u as=0.7866p ps=2.52u w=1.38u l=0.28u
X10 VSS.t1 B.t0 a_500_24# VPW.t1 nfet_03v3 ad=0.26p pd=1.52u as=0.31p ps=1.62u w=1u l=0.28u
X11 VSS.t3 a_556_68# Y.t6 VPW.t5 nfet_03v3 ad=0.56p pd=3.12u as=0.26p ps=1.52u w=1u l=0.28u
X12 VDD.t3 a_556_68# Y.t1 VNW.t5 pfet_03v3 ad=0.7314p pd=3.82u as=0.3588p ps=1.9u w=1.38u l=0.28u
X13 a_444_68# a_28_68# VSS.t0 VPW.t0 nfet_03v3 ad=0.14p pd=1.28u as=0.54p ps=2.08u w=1u l=0.28u
X14 Y.t5 a_556_68# VSS.t2 VPW.t4 nfet_03v3 ad=0.26p pd=1.52u as=0.26p ps=1.52u w=1u l=0.28u
X15 Y.t2 a_556_68# VDD.t0 VNW.t2 pfet_03v3 ad=0.3933p pd=1.95u as=0.3588p ps=1.9u w=1.38u l=0.28u
X16 VDD.t5 A.t3 a_28_68# VNW.t7 pfet_03v3 ad=0.3588p pd=1.9u as=0.6072p ps=3.64u w=1.38u l=0.28u
X17 a_556_68# a_500_24# a_332_440# VNW.t6 pfet_03v3 ad=0.4968p pd=2.1u as=0.5796p ps=2.22u w=1.38u l=0.28u
R0 VSS.n4 VSS.n1 6.38659
R1 VSS.n5 VSS.n0 6.38659
R2 VSS.n3 VSS.t3 5.2398
R3 VSS.n0 VSS.t0 5.1665
R4 VSS.n3 VSS.n2 3.3618
R5 VSS.n2 VSS.t2 1.6385
R6 VSS.n2 VSS.t5 1.6385
R7 VSS.n1 VSS.t4 1.6385
R8 VSS.n1 VSS.t1 1.6385
R9 VSS.n0 VSS.t6 1.6385
R10 VSS.n5 VSS.n4 0.6515
R11 VSS.n4 VSS.n3 0.248
R12 VSS VSS.n5 0.1685
R13 Y.n7 Y.n6 6.3005
R14 Y.n3 Y.n2 6.3005
R15 Y.n4 Y.n1 2.9065
R16 Y.n5 Y.n0 2.85909
R17 Y.n6 Y.t3 1.9535
R18 Y.n2 Y.t6 1.6385
R19 Y.n2 Y.t5 1.6385
R20 Y.n6 Y.t4 1.6385
R21 Y.n0 Y.t2 1.57296
R22 Y.n1 Y.t1 1.31934
R23 Y.n1 Y.t0 1.31934
R24 Y.n0 Y.t7 1.31934
R25 Y.n5 Y.n4 0.487674
R26 Y.n4 Y.n3 0.1865
R27 Y.n7 Y.n5 0.157683
R28 Y.n3 Y 0.0515
R29 Y Y.n7 0.0435986
R30 VDD.n5 VDD.n0 5.28659
R31 VDD.n4 VDD.n1 5.28659
R32 VDD.n3 VDD.t3 3.57833
R33 VDD.n3 VDD.n2 2.01949
R34 VDD.n0 VDD.t4 1.31934
R35 VDD.n0 VDD.t5 1.31934
R36 VDD.n1 VDD.t0 1.31934
R37 VDD.n1 VDD.t6 1.31934
R38 VDD.n2 VDD.t2 1.31934
R39 VDD.n2 VDD.t1 1.31934
R40 VDD.n5 VDD.n4 0.6515
R41 VDD.n4 VDD.n3 0.248
R42 VDD VDD.n5 0.1685
R43 B.n0 B.t1 27.7048
R44 B.n0 B.t0 23.2727
R45 B B.n0 8.03774
R46 A.n2 A.t0 41.8235
R47 A.n0 A.t2 36.9256
R48 A.n0 A.t3 22.8061
R49 A.n1 A.t1 22.7513
R50 A.n2 A.n1 8.0005
R51 A.n1 A.n0 4.32287
R52 A A.n2 0.0413
R53 VNW.t0 VNW.t1 550.389
R54 VNW.t8 VNW.t6 434.11
R55 VNW.t6 VNW.t0 387.598
R56 VNW.t2 VNW.t3 329.457
R57 VNW.t4 VNW.t5 310.079
R58 VNW.t3 VNW.t4 310.079
R59 VNW.t1 VNW.t2 310.079
R60 VNW.t7 VNW.t8 310.079
R61 VNW VNW.t7 259.69
R62 VPW.t6 VPW.t8 2245.45
R63 VPW.t7 VPW.t0 2009.09
R64 VPW.t8 VPW.t1 1329.55
R65 VPW.t2 VPW.t3 1255.68
R66 VPW.t4 VPW.t5 1181.82
R67 VPW.t3 VPW.t4 1181.82
R68 VPW.t1 VPW.t2 1181.82
R69 VPW VPW.t7 989.774
R70 VPW.t0 VPW.t6 827.274
C0 Y A 0.00218f
C1 Y a_332_440# 0
C2 Y VNW 0.04022f
C3 a_444_68# VSS 0.0055f
C4 Y B 0.00307f
C5 Y VDD 0.59065f
C6 Y a_500_24# 0.02147f
C7 a_556_68# VSS 0.19017f
C8 A VSS 0.12088f
C9 a_332_440# VSS 0.00158f
C10 VSS VNW 0.01282f
C11 B VSS 0.03696f
C12 a_444_68# a_556_68# 0.00253f
C13 VDD VSS 0.03998f
C14 Y a_28_68# 0.00749f
C15 a_444_68# A 0.00363f
C16 VSS a_500_24# 0.05439f
C17 a_444_68# VDD 0
C18 A a_556_68# 0.22544f
C19 a_556_68# a_332_440# 0.009f
C20 A a_332_440# 0.02207f
C21 a_556_68# VNW 0.35876f
C22 A VNW 0.21169f
C23 a_28_68# VSS 0.17301f
C24 B a_556_68# 0.16936f
C25 A B 0.01877f
C26 a_556_68# VDD 0.41791f
C27 A VDD 0.12048f
C28 VDD a_332_440# 0.0172f
C29 a_556_68# a_500_24# 0.8026f
C30 B VNW 0.07821f
C31 A a_500_24# 0.29731f
C32 VDD VNW 0.28017f
C33 VNW a_500_24# 0.11241f
C34 a_444_68# a_28_68# 0.00114f
C35 B VDD 0.01704f
C36 B a_500_24# 0.10446f
C37 VDD a_500_24# 0.03306f
C38 a_28_68# a_556_68# 0.28764f
C39 A a_28_68# 0.77778f
C40 a_28_68# a_332_440# 0.01662f
C41 a_28_68# VNW 0.16244f
C42 a_28_68# B 0.00835f
C43 a_28_68# VDD 0.19251f
C44 a_28_68# a_500_24# 0.27998f
C45 Y VSS 0.25869f
C46 Y a_556_68# 0.46693f
C47 VSS VPW 0.69287f
C48 Y VPW 0.05584f
C49 VDD VPW 0.50656f
C50 B VPW 0.16472f
C51 A VPW 0.37277f
C52 VNW VPW 3.31232f
C53 a_556_68# VPW 0.43432f
C54 a_28_68# VPW 0.36497f
C55 a_500_24# VPW 0.1172f
C56 VNW.t5 VPW 0.24699f
C57 VNW.t4 VPW 0.09686f
C58 VNW.t3 VPW 0.09988f
C59 VNW.t2 VPW 0.09988f
C60 VNW.t1 VPW 0.13439f
C61 VNW.t0 VPW 0.1465f
C62 VNW.t6 VPW 0.12834f
C63 VNW.t8 VPW 0.11623f
C64 VNW.t7 VPW 0.08899f
C65 A.t0 VPW 0.24988f
C66 A.t2 VPW 0.15568f
C67 A.t3 VPW 0.11919f
C68 A.n0 VPW 0.17054f
C69 A.t1 VPW 0.09485f
C70 A.n1 VPW 0.09057f
C71 A.n2 VPW 0.90463f
C72 B.t1 VPW 0.12336f
C73 B.t0 VPW 0.08988f
C74 B.n0 VPW 0.14534f
C75 VDD.t4 VPW 0.03249f
C76 VDD.t5 VPW 0.03249f
C77 VDD.n0 VPW 0.06517f
C78 VDD.t0 VPW 0.03249f
C79 VDD.t6 VPW 0.03249f
C80 VDD.n1 VPW 0.06517f
C81 VDD.t2 VPW 0.03249f
C82 VDD.t1 VPW 0.03249f
C83 VDD.n2 VPW 0.07135f
C84 VDD.t3 VPW 0.11501f
C85 VDD.n3 VPW 0.48321f
C86 VDD.n4 VPW 0.3415f
C87 VDD.n5 VPW 0.31271f
C88 Y.t7 VPW 0.05605f
C89 Y.t2 VPW 0.06683f
C90 Y.n0 VPW 0.13392f
C91 Y.t1 VPW 0.05605f
C92 Y.t0 VPW 0.05605f
C93 Y.n1 VPW 0.12296f
C94 Y.t6 VPW 0.04062f
C95 Y.t5 VPW 0.04062f
C96 Y.n2 VPW 0.08123f
C97 Y.n3 VPW 0.03702f
C98 Y.n4 VPW 0.21384f
C99 Y.n5 VPW 0.24666f
C100 Y.t4 VPW 0.04062f
C101 Y.t3 VPW 0.04843f
C102 Y.n6 VPW 0.08905f
C103 Y.n7 VPW 0.04381f
C104 VSS.t0 VPW 0.04043f
C105 VSS.t6 VPW 0.01282f
C106 VSS.n0 VPW 0.05333f
C107 VSS.t4 VPW 0.01282f
C108 VSS.t1 VPW 0.01282f
C109 VSS.n1 VPW 0.02572f
C110 VSS.t2 VPW 0.01282f
C111 VSS.t5 VPW 0.01282f
C112 VSS.n2 VPW 0.02679f
C113 VSS.t3 VPW 0.04818f
C114 VSS.n3 VPW 0.24605f
C115 VSS.n4 VPW 0.18596f
C116 VSS.n5 VPW 0.17028f
.ends

* NGSPICE file created from gf180mcu_as_sc_mcu7t3v3__xor2_2.ext - technology: gf180mcuD

.subckt gf180mcu_as_sc_mcu7t3v3__xor2_2 VDD VNW VPW VSS B A Y
X0 VSS.t3 a_556_68# Y.t3 VPW.t4 nfet_03v3 ad=0.85p pd=3.7u as=0.285p ps=1.57u w=1u l=0.28u
X1 VDD.t3 a_556_68# Y.t1 VNW.t4 pfet_03v3 ad=1.173p pd=4.46u as=0.3933p ps=1.95u w=1.38u l=0.28u
X2 Y.t2 a_556_68# VSS.t2 VPW.t3 nfet_03v3 ad=0.285p pd=1.57u as=0.26p ps=1.52u w=1u l=0.28u
X3 a_332_440# a_28_68# VDD.t1 VNW.t1 pfet_03v3 ad=0.5796p pd=2.22u as=0.3588p ps=1.9u w=1.38u l=0.28u
X4 VSS.t1 A.t1 a_28_68# VPW.t5 nfet_03v3 ad=0.54p pd=2.08u as=0.44p ps=2.88u w=1u l=0.28u
X5 a_556_68# a_500_24# a_444_68# VPW.t0 nfet_03v3 ad=0.62p pd=2.24u as=0.14p ps=1.28u w=1u l=0.28u
X6 a_500_24# a_28_68# a_556_68# VPW.t1 nfet_03v3 ad=0.31p pd=1.62u as=0.62p ps=2.24u w=1u l=0.28u
X7 a_500_24# A.t2 a_556_68# VNW.t6 pfet_03v3 ad=0.7866p pd=2.52u as=0.4968p ps=2.1u w=1.38u l=0.28u
X8 VDD.t4 B.t1 a_500_24# VNW.t2 pfet_03v3 ad=0.3588p pd=1.9u as=0.7866p ps=2.52u w=1.38u l=0.28u
X9 VSS.t4 B.t0 a_500_24# VPW.t2 nfet_03v3 ad=0.26p pd=1.52u as=0.31p ps=1.62u w=1u l=0.28u
X10 a_444_68# A.t0 VSS.t0 VPW.t6 nfet_03v3 ad=0.14p pd=1.28u as=0.54p ps=2.08u w=1u l=0.28u
X11 Y.t0 a_556_68# VDD.t2 VNW.t3 pfet_03v3 ad=0.3933p pd=1.95u as=0.3588p ps=1.9u w=1.38u l=0.28u
X12 VDD.t0 A.t3 a_28_68# VNW.t5 pfet_03v3 ad=0.3588p pd=1.9u as=0.6072p ps=3.64u w=1.38u l=0.28u
X13 a_556_68# a_500_24# a_332_440# VNW.t0 pfet_03v3 ad=0.4968p pd=2.1u as=0.5796p ps=2.22u w=1.38u l=0.28u
R0 VSS.n2 VSS.n1 6.38659
R1 VSS.n3 VSS.n0 6.38659
R2 VSS.n2 VSS.t3 5.2473
R3 VSS.n0 VSS.t0 5.1665
R4 VSS.n1 VSS.t2 1.6385
R5 VSS.n1 VSS.t4 1.6385
R6 VSS.n0 VSS.t1 1.6385
R7 VSS.n3 VSS.n2 0.6515
R8 VSS VSS.n3 0.1685
R9 Y.n2 Y.n1 6.3005
R10 Y.n2 Y.n0 3.01627
R11 Y.n1 Y.t2 1.9535
R12 Y.n1 Y.t3 1.6385
R13 Y.n0 Y.t0 1.57296
R14 Y.n0 Y.t1 1.31934
R15 Y Y.n2 0.0435986
R16 VDD.n3 VDD.n0 5.28659
R17 VDD.n2 VDD.n1 5.28659
R18 VDD.n2 VDD.t3 3.58583
R19 VDD.n0 VDD.t1 1.31934
R20 VDD.n0 VDD.t0 1.31934
R21 VDD.n1 VDD.t2 1.31934
R22 VDD.n1 VDD.t4 1.31934
R23 VDD.n3 VDD.n2 0.6515
R24 VDD VDD.n3 0.1685
R25 B.n0 B.t1 27.7048
R26 B.n0 B.t0 23.2727
R27 B B.n0 8.03774
R28 A.n0 A.t2 41.7884
R29 A.n0 A.t0 35.907
R30 A.n1 A.t3 27.1285
R31 A.n1 A.t1 22.7513
R32 A.n2 A.n1 8.0005
R33 A.n2 A.n0 5.62678
R34 A A.n2 0.0413
R35 VNW.t6 VNW.t2 550.389
R36 VNW.t1 VNW.t0 434.11
R37 VNW.t0 VNW.t6 387.598
R38 VNW.t3 VNW.t4 329.457
R39 VNW.t2 VNW.t3 310.079
R40 VNW.t5 VNW.t1 310.079
R41 VNW VNW.t5 259.69
R42 VPW.t0 VPW.t1 2245.45
R43 VPW.t5 VPW.t6 2009.09
R44 VPW.t1 VPW.t2 1329.55
R45 VPW.t3 VPW.t4 1255.68
R46 VPW.t2 VPW.t3 1181.82
R47 VPW VPW.t5 989.774
R48 VPW.t6 VPW.t0 827.274
C0 A VSS 0.03641f
C1 A VDD 0.15449f
C2 a_28_68# a_500_24# 0.31333f
C3 VSS a_500_24# 0.0456f
C4 A Y 0.00621f
C5 VNW B 0.07821f
C6 a_500_24# VDD 0.03277f
C7 A a_332_440# 0.03372f
C8 a_500_24# Y 0.01955f
C9 a_28_68# VSS 0.70427f
C10 A a_444_68# 0
C11 a_28_68# VDD 0.22986f
C12 A VNW 0.20953f
C13 VSS VDD 0.03915f
C14 B a_556_68# 0.16979f
C15 a_28_68# Y 0
C16 a_28_68# a_332_440# 0.00866f
C17 VNW a_500_24# 0.11189f
C18 VSS Y 0.08185f
C19 VDD Y 0.2308f
C20 VDD a_332_440# 0.01485f
C21 A a_556_68# 0.44344f
C22 Y a_332_440# 0
C23 a_28_68# a_444_68# 0.00794f
C24 a_28_68# VNW 0.14391f
C25 VSS a_444_68# 0.00175f
C26 a_444_68# VDD 0
C27 VSS VNW 0.00856f
C28 VNW VDD 0.21658f
C29 a_500_24# a_556_68# 0.81175f
C30 A B 0.0085f
C31 VNW Y 0.02003f
C32 a_28_68# a_556_68# 0.23817f
C33 B a_500_24# 0.10446f
C34 VSS a_556_68# 0.08143f
C35 VDD a_556_68# 0.35783f
C36 a_556_68# Y 0.37931f
C37 a_556_68# a_332_440# 0.00559f
C38 a_28_68# B 0.01853f
C39 A a_500_24# 0.28241f
C40 VSS B 0.03688f
C41 B VDD 0.01702f
C42 a_444_68# a_556_68# 0.00203f
C43 B Y 0.00284f
C44 VNW a_556_68# 0.18135f
C45 A a_28_68# 0.98692f
C46 VSS VPW 0.59609f
C47 Y VPW 0.03721f
C48 VDD VPW 0.4381f
C49 B VPW 0.16473f
C50 A VPW 0.44663f
C51 VNW VPW 2.78439f
C52 a_556_68# VPW 0.22337f
C53 a_500_24# VPW 0.11743f
C54 a_28_68# VPW 0.23043f
C55 VNW.t4 VPW 0.22133f
C56 VNW.t3 VPW 0.09199f
C57 VNW.t2 VPW 0.12377f
C58 VNW.t6 VPW 0.13492f
C59 VNW.t0 VPW 0.11819f
C60 VNW.t1 VPW 0.10704f
C61 VNW.t5 VPW 0.08195f
C62 A.t2 VPW 0.20017f
C63 A.t0 VPW 0.1764f
C64 A.n0 VPW 1.16307f
C65 A.t3 VPW 0.14572f
C66 A.t1 VPW 0.10399f
C67 A.n1 VPW 0.17867f
C68 A.n2 VPW 0.17825f
C69 B.t1 VPW 0.12336f
C70 B.t0 VPW 0.08988f
C71 B.n0 VPW 0.14535f
C72 VDD.t1 VPW 0.02967f
C73 VDD.t0 VPW 0.02967f
C74 VDD.n0 VPW 0.05951f
C75 VDD.t2 VPW 0.02967f
C76 VDD.t4 VPW 0.02967f
C77 VDD.n1 VPW 0.05951f
C78 VDD.t3 VPW 0.15127f
C79 VDD.n2 VPW 0.56384f
C80 VDD.n3 VPW 0.28556f
C81 Y.t1 VPW 0.06024f
C82 Y.t0 VPW 0.07182f
C83 Y.n0 VPW 0.15523f
C84 Y.t3 VPW 0.04365f
C85 Y.t2 VPW 0.05204f
C86 Y.n1 VPW 0.0957f
C87 Y.n2 VPW 0.25278f
C88 VSS.t0 VPW 0.05603f
C89 VSS.t1 VPW 0.01776f
C90 VSS.n0 VPW 0.07391f
C91 VSS.t2 VPW 0.01776f
C92 VSS.t4 VPW 0.01776f
C93 VSS.n1 VPW 0.03565f
C94 VSS.t3 VPW 0.09407f
C95 VSS.n2 VPW 0.44108f
C96 VSS.n3 VPW 0.23598f
.ends

* NGSPICE file created from gf180mcu_as_sc_mcu7t3v3__xor2_4.ext - technology: gf180mcuD

.subckt gf180mcu_as_sc_mcu7t3v3__xor2_4 VDD VNW VPW VSS B A Y
X0 VSS.t5 a_556_68# Y.t2 VPW.t4 nfet_03v3 ad=0.26p pd=1.52u as=0.285p ps=1.57u w=1u l=0.28u
X1 VDD.t4 a_556_68# Y.t0 VNW.t4 pfet_03v3 ad=0.3588p pd=1.9u as=0.3933p ps=1.95u w=1.38u l=0.28u
X2 Y.t1 a_556_68# VSS.t3 VPW.t3 nfet_03v3 ad=0.285p pd=1.57u as=0.26p ps=1.52u w=1u l=0.28u
X3 a_332_440# a_28_68# VDD.t0 VNW.t1 pfet_03v3 ad=0.5796p pd=2.22u as=0.3588p ps=1.9u w=1.38u l=0.28u
X4 VSS.t2 A.t1 a_28_68# VPW.t7 nfet_03v3 ad=0.54p pd=2.08u as=0.44p ps=2.88u w=1u l=0.28u
X5 a_556_68# a_500_24# a_444_68# VPW.t2 nfet_03v3 ad=0.62p pd=2.24u as=0.14p ps=1.28u w=1u l=0.28u
X6 Y.t5 a_556_68# VDD.t5 VNW.t5 pfet_03v3 ad=0.3588p pd=1.9u as=0.3588p ps=1.9u w=1.38u l=0.28u
X7 a_500_24# a_28_68# a_556_68# VPW.t1 nfet_03v3 ad=0.31p pd=1.62u as=0.62p ps=2.24u w=1u l=0.28u
X8 a_500_24# A.t2 a_556_68# VNW.t8 pfet_03v3 ad=0.7866p pd=2.52u as=0.4968p ps=2.1u w=1.38u l=0.28u
X9 VDD.t1 B.t1 a_500_24# VNW.t0 pfet_03v3 ad=0.3588p pd=1.9u as=0.7866p ps=2.52u w=1.38u l=0.28u
X10 VSS.t0 B.t0 a_500_24# VPW.t0 nfet_03v3 ad=0.26p pd=1.52u as=0.31p ps=1.62u w=1u l=0.28u
X11 VSS.t4 a_556_68# Y.t4 VPW.t6 nfet_03v3 ad=0.725p pd=3.45u as=0.26p ps=1.52u w=1u l=0.28u
X12 VDD.t6 a_556_68# Y.t6 VNW.t6 pfet_03v3 ad=1.0005p pd=4.21u as=0.3588p ps=1.9u w=1.38u l=0.28u
X13 a_444_68# A.t0 VSS.t1 VPW.t8 nfet_03v3 ad=0.14p pd=1.28u as=0.54p ps=2.08u w=1u l=0.28u
X14 Y.t3 a_556_68# VSS.t6 VPW.t5 nfet_03v3 ad=0.26p pd=1.52u as=0.26p ps=1.52u w=1u l=0.28u
X15 Y.t7 a_556_68# VDD.t3 VNW.t3 pfet_03v3 ad=0.3933p pd=1.95u as=0.3588p ps=1.9u w=1.38u l=0.28u
X16 VDD.t2 A.t3 a_28_68# VNW.t7 pfet_03v3 ad=0.3588p pd=1.9u as=0.6072p ps=3.64u w=1.38u l=0.28u
X17 a_556_68# a_500_24# a_332_440# VNW.t2 pfet_03v3 ad=0.4968p pd=2.1u as=0.5796p ps=2.22u w=1.38u l=0.28u
R0 VSS.n4 VSS.n1 6.38659
R1 VSS.n5 VSS.n0 6.38659
R2 VSS.n3 VSS.t4 5.2398
R3 VSS.n0 VSS.t1 5.1665
R4 VSS.n3 VSS.n2 3.3618
R5 VSS.n2 VSS.t6 1.6385
R6 VSS.n2 VSS.t5 1.6385
R7 VSS.n1 VSS.t3 1.6385
R8 VSS.n1 VSS.t0 1.6385
R9 VSS.n0 VSS.t2 1.6385
R10 VSS.n5 VSS.n4 0.6515
R11 VSS.n4 VSS.n3 0.248
R12 VSS VSS.n5 0.1685
R13 Y.n3 Y.n2 6.3005
R14 Y.n6 Y.n5 6.3005
R15 Y Y.n1 2.86163
R16 Y.n4 Y.n0 2.86163
R17 Y.n2 Y.t1 1.9535
R18 Y.n2 Y.t2 1.6385
R19 Y.n5 Y.t4 1.6385
R20 Y.n5 Y.t3 1.6385
R21 Y.n1 Y.t7 1.57296
R22 Y.n1 Y.t0 1.31934
R23 Y.n0 Y.t6 1.31934
R24 Y.n0 Y.t5 1.31934
R25 Y.n4 Y 0.334978
R26 Y Y.n3 0.155148
R27 Y.n6 Y.n4 0.155148
R28 Y.n3 Y 0.0435986
R29 Y Y.n6 0.0435986
R30 VDD.n5 VDD.n0 5.28659
R31 VDD.n4 VDD.n1 5.28659
R32 VDD.n3 VDD.t6 3.57833
R33 VDD.n3 VDD.n2 2.01949
R34 VDD.n0 VDD.t0 1.31934
R35 VDD.n0 VDD.t2 1.31934
R36 VDD.n1 VDD.t3 1.31934
R37 VDD.n1 VDD.t1 1.31934
R38 VDD.n2 VDD.t5 1.31934
R39 VDD.n2 VDD.t4 1.31934
R40 VDD.n5 VDD.n4 0.6515
R41 VDD.n4 VDD.n3 0.248
R42 VDD VDD.n5 0.1685
R43 B.n0 B.t1 27.7048
R44 B.n0 B.t0 23.2727
R45 B B.n0 8.03774
R46 A.n0 A.t2 41.7884
R47 A.n0 A.t0 35.9102
R48 A.n1 A.t3 27.1285
R49 A.n1 A.t1 22.7513
R50 A.n2 A.n1 8.0005
R51 A.n2 A.n0 5.62678
R52 A A.n2 0.0413
R53 VNW.t8 VNW.t0 550.389
R54 VNW.t1 VNW.t2 434.11
R55 VNW.t2 VNW.t8 387.598
R56 VNW.t3 VNW.t4 329.457
R57 VNW.t5 VNW.t6 310.079
R58 VNW.t4 VNW.t5 310.079
R59 VNW.t0 VNW.t3 310.079
R60 VNW.t7 VNW.t1 310.079
R61 VNW VNW.t7 259.69
R62 VPW.t2 VPW.t1 2245.45
R63 VPW.t7 VPW.t8 2009.09
R64 VPW.t1 VPW.t0 1329.55
R65 VPW.t3 VPW.t4 1255.68
R66 VPW.t5 VPW.t6 1181.82
R67 VPW.t4 VPW.t5 1181.82
R68 VPW.t0 VPW.t3 1181.82
R69 VPW VPW.t7 989.774
R70 VPW.t8 VPW.t2 827.274
C0 VDD a_500_24# 0.03277f
C1 VNW VDD 0.27561f
C2 a_500_24# B 0.10446f
C3 VNW B 0.07821f
C4 A a_500_24# 0.28506f
C5 Y a_500_24# 0.02118f
C6 VSS a_500_24# 0.0456f
C7 VNW A 0.20953f
C8 VNW Y 0.038f
C9 a_500_24# a_556_68# 0.80515f
C10 VNW VSS 0.01013f
C11 VDD a_444_68# 0
C12 VNW a_556_68# 0.3571f
C13 VDD B 0.01702f
C14 a_444_68# A 0
C15 VDD A 0.15473f
C16 VDD Y 0.62616f
C17 a_444_68# VSS 0.00175f
C18 VDD VSS 0.03873f
C19 a_444_68# a_556_68# 0.00203f
C20 A B 0.0085f
C21 Y B 0.00304f
C22 VDD a_556_68# 0.41578f
C23 VSS B 0.03688f
C24 Y A 0.00806f
C25 B a_556_68# 0.16942f
C26 VSS A 0.03641f
C27 Y VSS 0.28062f
C28 A a_556_68# 0.44519f
C29 Y a_556_68# 0.4767f
C30 VSS a_556_68# 0.13498f
C31 a_500_24# a_28_68# 0.30067f
C32 VNW a_28_68# 0.14352f
C33 VDD a_332_440# 0.01485f
C34 a_332_440# A 0.03379f
C35 a_332_440# Y 0
C36 a_444_68# a_28_68# 0.00794f
C37 VDD a_28_68# 0.22986f
C38 a_332_440# a_556_68# 0.00559f
C39 B a_28_68# 0.01847f
C40 A a_28_68# 0.97581f
C41 Y a_28_68# 0
C42 VSS a_28_68# 0.70427f
C43 a_28_68# a_556_68# 0.23847f
C44 a_332_440# a_28_68# 0.00873f
C45 VNW a_500_24# 0.11225f
C46 VSS VPW 0.69872f
C47 Y VPW 0.31972f
C48 VDD VPW 0.50791f
C49 B VPW 0.16469f
C50 A VPW 0.44223f
C51 VNW VPW 3.30978f
C52 a_556_68# VPW 0.4353f
C53 a_500_24# VPW 0.11735f
C54 a_28_68# VPW 0.23021f
C55 VNW.t6 VPW 0.24062f
C56 VNW.t5 VPW 0.09436f
C57 VNW.t4 VPW 0.09731f
C58 VNW.t3 VPW 0.09731f
C59 VNW.t0 VPW 0.13093f
C60 VNW.t8 VPW 0.14272f
C61 VNW.t2 VPW 0.12503f
C62 VNW.t1 VPW 0.11324f
C63 VNW.t7 VPW 0.0867f
C64 A.t2 VPW 0.19991f
C65 A.t0 VPW 0.17592f
C66 A.n0 VPW 1.16032f
C67 A.t3 VPW 0.14547f
C68 A.t1 VPW 0.10381f
C69 A.n1 VPW 0.17835f
C70 A.n2 VPW 0.17794f
C71 B.t1 VPW 0.1233f
C72 B.t0 VPW 0.08983f
C73 B.n0 VPW 0.14527f
C74 VDD.t0 VPW 0.03337f
C75 VDD.t2 VPW 0.03337f
C76 VDD.n0 VPW 0.06694f
C77 VDD.t3 VPW 0.03337f
C78 VDD.t1 VPW 0.03337f
C79 VDD.n1 VPW 0.06694f
C80 VDD.t5 VPW 0.03337f
C81 VDD.t4 VPW 0.03337f
C82 VDD.n2 VPW 0.07328f
C83 VDD.t6 VPW 0.1497f
C84 VDD.n3 VPW 0.51457f
C85 VDD.n4 VPW 0.35076f
C86 VDD.n5 VPW 0.32118f
C87 Y.t6 VPW 0.05535f
C88 Y.t5 VPW 0.05535f
C89 Y.n0 VPW 0.12174f
C90 Y.t0 VPW 0.05535f
C91 Y.t7 VPW 0.06599f
C92 Y.n1 VPW 0.13239f
C93 Y.t2 VPW 0.04011f
C94 Y.t1 VPW 0.04782f
C95 Y.n2 VPW 0.08793f
C96 Y.n3 VPW 0.04271f
C97 Y.n4 VPW 0.26412f
C98 Y.t4 VPW 0.04011f
C99 Y.t3 VPW 0.04011f
C100 Y.n5 VPW 0.08021f
C101 Y.n6 VPW 0.04271f
C102 VSS.t1 VPW 0.05727f
C103 VSS.t2 VPW 0.01816f
C104 VSS.n0 VPW 0.07555f
C105 VSS.t3 VPW 0.01816f
C106 VSS.t0 VPW 0.01816f
C107 VSS.n1 VPW 0.03644f
C108 VSS.t6 VPW 0.01816f
C109 VSS.t5 VPW 0.01816f
C110 VSS.n2 VPW 0.03794f
C111 VSS.t4 VPW 0.08409f
C112 VSS.n3 VPW 0.35574f
C113 VSS.n4 VPW 0.26341f
C114 VSS.n5 VPW 0.2412f
.ends
